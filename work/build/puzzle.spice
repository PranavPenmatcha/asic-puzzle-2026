* NGSPICE file created from puzzle.ext - technology: sky130A

.subckt sky130_fd_sc_hd__nor4_2 C D Y A B VGND VPWR VPB VNB
X0 a_281_297# B a_27_297# VPB sky130_fd_pr__pfet_01v8_hvt ad=0.135 pd=1.27 as=0.135 ps=1.27 w=1 l=0.15
X1 Y B VGND VNB sky130_fd_pr__nfet_01v8 ad=0.08775 pd=0.92 as=0.08775 ps=0.92 w=0.65 l=0.15
X2 a_27_297# A VPWR VPB sky130_fd_pr__pfet_01v8_hvt ad=0.135 pd=1.27 as=0.135 ps=1.27 w=1 l=0.15
X3 a_475_297# D Y VPB sky130_fd_pr__pfet_01v8_hvt ad=0.26 pd=2.52 as=0.135 ps=1.27 w=1 l=0.15
X4 VGND C Y VNB sky130_fd_pr__nfet_01v8 ad=0.08775 pd=0.92 as=0.08775 ps=0.92 w=0.65 l=0.15
X5 Y D a_475_297# VPB sky130_fd_pr__pfet_01v8_hvt ad=0.135 pd=1.27 as=0.135 ps=1.27 w=1 l=0.15
X6 VGND D Y VNB sky130_fd_pr__nfet_01v8 ad=0.169 pd=1.82 as=0.08775 ps=0.92 w=0.65 l=0.15
X7 VGND A Y VNB sky130_fd_pr__nfet_01v8 ad=0.08775 pd=0.92 as=0.08775 ps=0.92 w=0.65 l=0.15
X8 Y A VGND VNB sky130_fd_pr__nfet_01v8 ad=0.08775 pd=0.92 as=0.182 ps=1.86 w=0.65 l=0.15
X9 VGND B Y VNB sky130_fd_pr__nfet_01v8 ad=0.182 pd=1.86 as=0.08775 ps=0.92 w=0.65 l=0.15
X10 Y D VGND VNB sky130_fd_pr__nfet_01v8 ad=0.08775 pd=0.92 as=0.08775 ps=0.92 w=0.65 l=0.15
X11 VPWR A a_27_297# VPB sky130_fd_pr__pfet_01v8_hvt ad=0.135 pd=1.27 as=0.28 ps=2.56 w=1 l=0.15
X12 a_475_297# C a_281_297# VPB sky130_fd_pr__pfet_01v8_hvt ad=0.135 pd=1.27 as=0.135 ps=1.27 w=1 l=0.15
X13 a_281_297# C a_475_297# VPB sky130_fd_pr__pfet_01v8_hvt ad=0.135 pd=1.27 as=0.28 ps=2.56 w=1 l=0.15
X14 a_27_297# B a_281_297# VPB sky130_fd_pr__pfet_01v8_hvt ad=0.28 pd=2.56 as=0.135 ps=1.27 w=1 l=0.15
X15 Y C VGND VNB sky130_fd_pr__nfet_01v8 ad=0.08775 pd=0.92 as=0.182 ps=1.86 w=0.65 l=0.15
.ends

.subckt sky130_fd_sc_hd__or2_2 B X A VPWR VGND VPB VNB
X0 a_121_297# B a_39_297# VPB sky130_fd_pr__pfet_01v8_hvt ad=0.0441 pd=0.63 as=0.1092 ps=1.36 w=0.42 l=0.15
X1 X a_39_297# VGND VNB sky130_fd_pr__nfet_01v8 ad=0.08775 pd=0.92 as=0.10675 ps=1.005 w=0.65 l=0.15
X2 VPWR a_39_297# X VPB sky130_fd_pr__pfet_01v8_hvt ad=0.26 pd=2.52 as=0.135 ps=1.27 w=1 l=0.15
X3 X a_39_297# VPWR VPB sky130_fd_pr__pfet_01v8_hvt ad=0.135 pd=1.27 as=0.15575 ps=1.355 w=1 l=0.15
X4 VGND a_39_297# X VNB sky130_fd_pr__nfet_01v8 ad=0.169 pd=1.82 as=0.08775 ps=0.92 w=0.65 l=0.15
X5 VPWR A a_121_297# VPB sky130_fd_pr__pfet_01v8_hvt ad=0.15575 pd=1.355 as=0.0441 ps=0.63 w=0.42 l=0.15
X6 VGND A a_39_297# VNB sky130_fd_pr__nfet_01v8 ad=0.10675 pd=1.005 as=0.0567 ps=0.69 w=0.42 l=0.15
X7 a_39_297# B VGND VNB sky130_fd_pr__nfet_01v8 ad=0.0567 pd=0.69 as=0.1092 ps=1.36 w=0.42 l=0.15
.ends

.subckt sky130_fd_sc_hd__and2b_2 X B A_N VPWR VGND VPB VNB
X0 VPWR a_212_413# X VPB sky130_fd_pr__pfet_01v8_hvt ad=0.26 pd=2.52 as=0.135 ps=1.27 w=1 l=0.15
X1 a_297_47# a_27_413# a_212_413# VNB sky130_fd_pr__nfet_01v8 ad=0.0567 pd=0.69 as=0.1092 ps=1.36 w=0.42 l=0.15
X2 X a_212_413# VPWR VPB sky130_fd_pr__pfet_01v8_hvt ad=0.135 pd=1.27 as=0.22895 ps=1.745 w=1 l=0.15
X3 X a_212_413# VGND VNB sky130_fd_pr__nfet_01v8 ad=0.08775 pd=0.92 as=0.101875 ps=0.99 w=0.65 l=0.15
X4 a_212_413# a_27_413# VPWR VPB sky130_fd_pr__pfet_01v8_hvt ad=0.0609 pd=0.71 as=0.07665 ps=0.785 w=0.42 l=0.15
X5 VPWR A_N a_27_413# VPB sky130_fd_pr__pfet_01v8_hvt ad=0.07665 pd=0.785 as=0.1092 ps=1.36 w=0.42 l=0.15
X6 VPWR B a_212_413# VPB sky130_fd_pr__pfet_01v8_hvt ad=0.22895 pd=1.745 as=0.0609 ps=0.71 w=0.42 l=0.15
X7 VGND B a_297_47# VNB sky130_fd_pr__nfet_01v8 ad=0.101875 pd=0.99 as=0.0567 ps=0.69 w=0.42 l=0.15
X8 VGND a_212_413# X VNB sky130_fd_pr__nfet_01v8 ad=0.1755 pd=1.84 as=0.08775 ps=0.92 w=0.65 l=0.15
X9 a_27_413# A_N VGND VNB sky130_fd_pr__nfet_01v8 ad=0.1092 pd=1.36 as=0.1092 ps=1.36 w=0.42 l=0.15
.ends

.subckt sky130_fd_sc_hd__o31ai_2 A1 Y B1 A3 A2 VGND VPWR VPB VNB
X0 a_281_297# A3 Y VPB sky130_fd_pr__pfet_01v8_hvt ad=0.135 pd=1.27 as=0.28 ps=2.56 w=1 l=0.15
X1 a_281_297# A2 a_27_297# VPB sky130_fd_pr__pfet_01v8_hvt ad=0.135 pd=1.27 as=0.135 ps=1.27 w=1 l=0.15
X2 VGND A2 a_27_47# VNB sky130_fd_pr__nfet_01v8 ad=0.19825 pd=1.26 as=0.08775 ps=0.92 w=0.65 l=0.15
X3 a_27_297# A1 VPWR VPB sky130_fd_pr__pfet_01v8_hvt ad=0.135 pd=1.27 as=0.135 ps=1.27 w=1 l=0.15
X4 a_27_47# A1 VGND VNB sky130_fd_pr__nfet_01v8 ad=0.08775 pd=0.92 as=0.08775 ps=0.92 w=0.65 l=0.15
X5 VGND A1 a_27_47# VNB sky130_fd_pr__nfet_01v8 ad=0.08775 pd=0.92 as=0.182 ps=1.86 w=0.65 l=0.15
X6 a_27_47# A3 VGND VNB sky130_fd_pr__nfet_01v8 ad=0.08775 pd=0.92 as=0.11375 ps=1 w=0.65 l=0.15
X7 VPWR B1 Y VPB sky130_fd_pr__pfet_01v8_hvt ad=0.195 pd=1.39 as=0.135 ps=1.27 w=1 l=0.15
X8 VPWR A1 a_27_297# VPB sky130_fd_pr__pfet_01v8_hvt ad=0.135 pd=1.27 as=0.28 ps=2.56 w=1 l=0.15
X9 a_27_47# B1 Y VNB sky130_fd_pr__nfet_01v8 ad=0.169 pd=1.82 as=0.12675 ps=1.04 w=0.65 l=0.15
X10 a_27_47# A2 VGND VNB sky130_fd_pr__nfet_01v8 ad=0.12675 pd=1.04 as=0.19825 ps=1.26 w=0.65 l=0.15
X11 VGND A3 a_27_47# VNB sky130_fd_pr__nfet_01v8 ad=0.11375 pd=1 as=0.12675 ps=1.04 w=0.65 l=0.15
X12 Y B1 a_27_47# VNB sky130_fd_pr__nfet_01v8 ad=0.12675 pd=1.04 as=0.08775 ps=0.92 w=0.65 l=0.15
X13 Y A3 a_281_297# VPB sky130_fd_pr__pfet_01v8_hvt ad=0.135 pd=1.27 as=0.135 ps=1.27 w=1 l=0.15
X14 Y B1 VPWR VPB sky130_fd_pr__pfet_01v8_hvt ad=0.26 pd=2.52 as=0.195 ps=1.39 w=1 l=0.15
X15 a_27_297# A2 a_281_297# VPB sky130_fd_pr__pfet_01v8_hvt ad=0.26 pd=2.52 as=0.135 ps=1.27 w=1 l=0.15
.ends

.subckt sky130_fd_sc_hd__decap_3 VPWR VGND VPB VNB
X0 VPWR VGND VPWR VPB sky130_fd_pr__pfet_01v8_hvt ad=0.2262 pd=2.26 as=0.4524 ps=4.52 w=0.87 l=0.59
X1 VGND VPWR VGND VNB sky130_fd_pr__nfet_01v8 ad=0.143 pd=1.62 as=0.286 ps=3.24 w=0.55 l=0.59
.ends

.subckt sky130_fd_sc_hd__a31o_2 X B1 A3 A1 A2 VGND VPWR VPB VNB
X0 VPWR A2 a_277_297# VPB sky130_fd_pr__pfet_01v8_hvt ad=0.165 pd=1.33 as=0.135 ps=1.27 w=1 l=0.15
X1 a_277_297# A1 VPWR VPB sky130_fd_pr__pfet_01v8_hvt ad=0.165 pd=1.33 as=0.165 ps=1.33 w=1 l=0.15
X2 a_79_21# B1 a_277_297# VPB sky130_fd_pr__pfet_01v8_hvt ad=0.32 pd=2.64 as=0.165 ps=1.33 w=1 l=0.15
X3 a_277_297# A3 VPWR VPB sky130_fd_pr__pfet_01v8_hvt ad=0.135 pd=1.27 as=0.135 ps=1.27 w=1 l=0.15
X4 VPWR a_79_21# X VPB sky130_fd_pr__pfet_01v8_hvt ad=0.135 pd=1.27 as=0.135 ps=1.27 w=1 l=0.15
X5 VGND a_79_21# X VNB sky130_fd_pr__nfet_01v8 ad=0.08775 pd=0.92 as=0.08775 ps=0.92 w=0.65 l=0.15
X6 a_361_47# A2 a_277_47# VNB sky130_fd_pr__nfet_01v8 ad=0.10725 pd=0.98 as=0.08775 ps=0.92 w=0.65 l=0.15
X7 a_277_47# A3 VGND VNB sky130_fd_pr__nfet_01v8 ad=0.08775 pd=0.92 as=0.08775 ps=0.92 w=0.65 l=0.15
X8 VGND B1 a_79_21# VNB sky130_fd_pr__nfet_01v8 ad=0.169 pd=1.82 as=0.12675 ps=1.04 w=0.65 l=0.15
X9 a_79_21# A1 a_361_47# VNB sky130_fd_pr__nfet_01v8 ad=0.12675 pd=1.04 as=0.10725 ps=0.98 w=0.65 l=0.15
X10 X a_79_21# VPWR VPB sky130_fd_pr__pfet_01v8_hvt ad=0.135 pd=1.27 as=0.26 ps=2.52 w=1 l=0.15
X11 X a_79_21# VGND VNB sky130_fd_pr__nfet_01v8 ad=0.08775 pd=0.92 as=0.169 ps=1.82 w=0.65 l=0.15
.ends

.subckt sky130_fd_sc_hd__and3_2 B X A C VPWR VGND VPB VNB
X0 VPWR a_29_311# X VPB sky130_fd_pr__pfet_01v8_hvt ad=0.26 pd=2.52 as=0.135 ps=1.27 w=1 l=0.15
X1 X a_29_311# VPWR VPB sky130_fd_pr__pfet_01v8_hvt ad=0.135 pd=1.27 as=0.15075 ps=1.345 w=1 l=0.15
X2 VPWR A a_29_311# VPB sky130_fd_pr__pfet_01v8_hvt ad=0.0567 pd=0.69 as=0.1092 ps=1.36 w=0.42 l=0.15
X3 VGND a_29_311# X VNB sky130_fd_pr__nfet_01v8 ad=0.17875 pd=1.85 as=0.08775 ps=0.92 w=0.65 l=0.15
X4 a_184_53# B a_112_53# VNB sky130_fd_pr__nfet_01v8 ad=0.05355 pd=0.675 as=0.0441 ps=0.63 w=0.42 l=0.15
X5 VPWR C a_29_311# VPB sky130_fd_pr__pfet_01v8_hvt ad=0.15075 pd=1.345 as=0.074375 ps=0.815 w=0.42 l=0.15
X6 X a_29_311# VGND VNB sky130_fd_pr__nfet_01v8 ad=0.08775 pd=0.92 as=0.1304 ps=1.105 w=0.65 l=0.15
X7 a_112_53# A a_29_311# VNB sky130_fd_pr__nfet_01v8 ad=0.0441 pd=0.63 as=0.1092 ps=1.36 w=0.42 l=0.15
X8 a_29_311# B VPWR VPB sky130_fd_pr__pfet_01v8_hvt ad=0.074375 pd=0.815 as=0.0567 ps=0.69 w=0.42 l=0.15
X9 VGND C a_184_53# VNB sky130_fd_pr__nfet_01v8 ad=0.1304 pd=1.105 as=0.05355 ps=0.675 w=0.42 l=0.15
.ends

.subckt sky130_fd_sc_hd__nand4_2 B A Y D C VGND VPWR VPB VNB
X0 VPWR C Y VPB sky130_fd_pr__pfet_01v8_hvt ad=0.215 pd=1.43 as=0.135 ps=1.27 w=1 l=0.15
X1 a_471_47# B a_277_47# VNB sky130_fd_pr__nfet_01v8 ad=0.08775 pd=0.92 as=0.08775 ps=0.92 w=0.65 l=0.15
X2 Y C VPWR VPB sky130_fd_pr__pfet_01v8_hvt ad=0.135 pd=1.27 as=0.135 ps=1.27 w=1 l=0.15
X3 VPWR D Y VPB sky130_fd_pr__pfet_01v8_hvt ad=0.135 pd=1.27 as=0.135 ps=1.27 w=1 l=0.15
X4 VPWR A Y VPB sky130_fd_pr__pfet_01v8_hvt ad=0.42 pd=2.84 as=0.135 ps=1.27 w=1 l=0.15
X5 a_27_47# D VGND VNB sky130_fd_pr__nfet_01v8 ad=0.08775 pd=0.92 as=0.08775 ps=0.92 w=0.65 l=0.15
X6 a_27_47# C a_277_47# VNB sky130_fd_pr__nfet_01v8 ad=0.182 pd=1.86 as=0.08775 ps=0.92 w=0.65 l=0.15
X7 Y A VPWR VPB sky130_fd_pr__pfet_01v8_hvt ad=0.135 pd=1.27 as=0.335 ps=1.67 w=1 l=0.15
X8 a_277_47# B a_471_47# VNB sky130_fd_pr__nfet_01v8 ad=0.08775 pd=0.92 as=0.182 ps=1.86 w=0.65 l=0.15
X9 VPWR B Y VPB sky130_fd_pr__pfet_01v8_hvt ad=0.335 pd=1.67 as=0.135 ps=1.27 w=1 l=0.15
X10 Y A a_471_47# VNB sky130_fd_pr__nfet_01v8 ad=0.08775 pd=0.92 as=0.08775 ps=0.92 w=0.65 l=0.15
X11 a_277_47# C a_27_47# VNB sky130_fd_pr__nfet_01v8 ad=0.08775 pd=0.92 as=0.08775 ps=0.92 w=0.65 l=0.15
X12 Y B VPWR VPB sky130_fd_pr__pfet_01v8_hvt ad=0.135 pd=1.27 as=0.215 ps=1.43 w=1 l=0.15
X13 a_471_47# A Y VNB sky130_fd_pr__nfet_01v8 ad=0.234 pd=2.02 as=0.08775 ps=0.92 w=0.65 l=0.15
X14 Y D VPWR VPB sky130_fd_pr__pfet_01v8_hvt ad=0.135 pd=1.27 as=0.26 ps=2.52 w=1 l=0.15
X15 VGND D a_27_47# VNB sky130_fd_pr__nfet_01v8 ad=0.08775 pd=0.92 as=0.169 ps=1.82 w=0.65 l=0.15
.ends

.subckt sky130_fd_sc_hd__or3_2 A B X C VGND VPWR VPB VNB
X0 VPWR a_30_53# X VPB sky130_fd_pr__pfet_01v8_hvt ad=0.315 pd=2.63 as=0.135 ps=1.27 w=1 l=0.15
X1 VGND a_30_53# X VNB sky130_fd_pr__nfet_01v8 ad=0.18525 pd=1.87 as=0.08775 ps=0.92 w=0.65 l=0.15
X2 X a_30_53# VPWR VPB sky130_fd_pr__pfet_01v8_hvt ad=0.135 pd=1.27 as=0.14825 ps=1.34 w=1 l=0.15
X3 a_112_297# C a_30_53# VPB sky130_fd_pr__pfet_01v8_hvt ad=0.0441 pd=0.63 as=0.1092 ps=1.36 w=0.42 l=0.15
X4 X a_30_53# VGND VNB sky130_fd_pr__nfet_01v8 ad=0.08775 pd=0.92 as=0.101875 ps=0.99 w=0.65 l=0.15
X5 VGND A a_30_53# VNB sky130_fd_pr__nfet_01v8 ad=0.101875 pd=0.99 as=0.0567 ps=0.69 w=0.42 l=0.15
X6 a_30_53# B VGND VNB sky130_fd_pr__nfet_01v8 ad=0.0567 pd=0.69 as=0.0567 ps=0.69 w=0.42 l=0.15
X7 VGND C a_30_53# VNB sky130_fd_pr__nfet_01v8 ad=0.0567 pd=0.69 as=0.1092 ps=1.36 w=0.42 l=0.15
X8 a_184_297# B a_112_297# VPB sky130_fd_pr__pfet_01v8_hvt ad=0.0693 pd=0.75 as=0.0441 ps=0.63 w=0.42 l=0.15
X9 VPWR A a_184_297# VPB sky130_fd_pr__pfet_01v8_hvt ad=0.14825 pd=1.34 as=0.0693 ps=0.75 w=0.42 l=0.15
.ends

.subckt sky130_fd_sc_hd__xnor2_2 Y A B VGND VPWR VPB VNB
X0 a_27_297# B VPWR VPB sky130_fd_pr__pfet_01v8_hvt ad=0.135 pd=1.27 as=0.135 ps=1.27 w=1 l=0.15
X1 a_560_47# A VGND VNB sky130_fd_pr__nfet_01v8 ad=0.08775 pd=0.92 as=0.182 ps=1.86 w=0.65 l=0.15
X2 VGND B a_560_47# VNB sky130_fd_pr__nfet_01v8 ad=0.169 pd=1.82 as=0.099125 ps=0.955 w=0.65 l=0.15
X3 Y B a_474_297# VPB sky130_fd_pr__pfet_01v8_hvt ad=0.1525 pd=1.305 as=0.135 ps=1.27 w=1 l=0.15
X4 VGND A a_27_47# VNB sky130_fd_pr__nfet_01v8 ad=0.08775 pd=0.92 as=0.08775 ps=0.92 w=0.65 l=0.15
X5 Y a_27_297# a_560_47# VNB sky130_fd_pr__nfet_01v8 ad=0.169 pd=1.82 as=0.08775 ps=0.92 w=0.65 l=0.15
X6 a_474_297# B Y VPB sky130_fd_pr__pfet_01v8_hvt ad=0.26 pd=2.52 as=0.1525 ps=1.305 w=1 l=0.15
X7 VGND A a_560_47# VNB sky130_fd_pr__nfet_01v8 ad=0.08775 pd=0.92 as=0.08775 ps=0.92 w=0.65 l=0.15
X8 a_27_47# B a_27_297# VNB sky130_fd_pr__nfet_01v8 ad=0.08775 pd=0.92 as=0.08775 ps=0.92 w=0.65 l=0.15
X9 a_27_297# B a_27_47# VNB sky130_fd_pr__nfet_01v8 ad=0.08775 pd=0.92 as=0.17875 ps=1.85 w=0.65 l=0.15
X10 a_27_47# A VGND VNB sky130_fd_pr__nfet_01v8 ad=0.182 pd=1.86 as=0.08775 ps=0.92 w=0.65 l=0.15
X11 VPWR B a_27_297# VPB sky130_fd_pr__pfet_01v8_hvt ad=0.135 pd=1.27 as=0.275 ps=2.55 w=1 l=0.15
X12 a_474_297# A VPWR VPB sky130_fd_pr__pfet_01v8_hvt ad=0.135 pd=1.27 as=0.135 ps=1.27 w=1 l=0.15
X13 a_560_47# a_27_297# Y VNB sky130_fd_pr__nfet_01v8 ad=0.08775 pd=0.92 as=0.169 ps=1.82 w=0.65 l=0.15
X14 VPWR A a_474_297# VPB sky130_fd_pr__pfet_01v8_hvt ad=0.135 pd=1.27 as=0.28 ps=2.56 w=1 l=0.15
X15 Y a_27_297# VPWR VPB sky130_fd_pr__pfet_01v8_hvt ad=0.135 pd=1.27 as=0.26 ps=2.52 w=1 l=0.15
X16 VPWR a_27_297# Y VPB sky130_fd_pr__pfet_01v8_hvt ad=0.28 pd=2.56 as=0.135 ps=1.27 w=1 l=0.15
X17 a_560_47# B VGND VNB sky130_fd_pr__nfet_01v8 ad=0.099125 pd=0.955 as=0.08775 ps=0.92 w=0.65 l=0.15
X18 a_27_297# A VPWR VPB sky130_fd_pr__pfet_01v8_hvt ad=0.28 pd=2.56 as=0.135 ps=1.27 w=1 l=0.15
X19 VPWR A a_27_297# VPB sky130_fd_pr__pfet_01v8_hvt ad=0.135 pd=1.27 as=0.135 ps=1.27 w=1 l=0.15
.ends

.subckt sky130_fd_sc_hd__and4bb_2 A_N C B_N X D VGND VPWR VPB VNB
X0 a_174_21# C VPWR VPB sky130_fd_pr__pfet_01v8_hvt ad=0.0567 pd=0.69 as=0.0588 ps=0.7 w=0.42 l=0.15
X1 a_174_21# a_27_47# VPWR VPB sky130_fd_pr__pfet_01v8_hvt ad=0.0672 pd=0.74 as=0.33075 ps=1.705 w=0.42 l=0.15
X2 a_476_47# a_27_47# a_174_21# VNB sky130_fd_pr__nfet_01v8 ad=0.0441 pd=0.63 as=0.1092 ps=1.36 w=0.42 l=0.15
X3 VPWR a_174_21# X VPB sky130_fd_pr__pfet_01v8_hvt ad=0.33075 pd=1.705 as=0.135 ps=1.27 w=1 l=0.15
X4 X a_174_21# VPWR VPB sky130_fd_pr__pfet_01v8_hvt ad=0.135 pd=1.27 as=0.14075 ps=1.325 w=1 l=0.15
X5 a_548_47# a_505_280# a_476_47# VNB sky130_fd_pr__nfet_01v8 ad=0.06405 pd=0.725 as=0.0441 ps=0.63 w=0.42 l=0.15
X6 VPWR A_N a_27_47# VPB sky130_fd_pr__pfet_01v8_hvt ad=0.14075 pd=1.325 as=0.1092 ps=1.36 w=0.42 l=0.15
X7 X a_174_21# VGND VNB sky130_fd_pr__nfet_01v8 ad=0.08775 pd=0.92 as=0.097 ps=0.975 w=0.65 l=0.15
X8 VPWR D a_174_21# VPB sky130_fd_pr__pfet_01v8_hvt ad=0.0924 pd=0.86 as=0.0567 ps=0.69 w=0.42 l=0.15
X9 VGND D a_639_47# VNB sky130_fd_pr__nfet_01v8 ad=0.0924 pd=0.86 as=0.0567 ps=0.69 w=0.42 l=0.15
X10 VPWR a_505_280# a_174_21# VPB sky130_fd_pr__pfet_01v8_hvt ad=0.0588 pd=0.7 as=0.0672 ps=0.74 w=0.42 l=0.15
X11 a_505_280# B_N VPWR VPB sky130_fd_pr__pfet_01v8_hvt ad=0.1092 pd=1.36 as=0.0924 ps=0.86 w=0.42 l=0.15
X12 VGND a_174_21# X VNB sky130_fd_pr__nfet_01v8 ad=0.169 pd=1.82 as=0.08775 ps=0.92 w=0.65 l=0.15
X13 a_505_280# B_N VGND VNB sky130_fd_pr__nfet_01v8 ad=0.1092 pd=1.36 as=0.0924 ps=0.86 w=0.42 l=0.15
X14 a_639_47# C a_548_47# VNB sky130_fd_pr__nfet_01v8 ad=0.0567 pd=0.69 as=0.06405 ps=0.725 w=0.42 l=0.15
X15 VGND A_N a_27_47# VNB sky130_fd_pr__nfet_01v8 ad=0.097 pd=0.975 as=0.1092 ps=1.36 w=0.42 l=0.15
.ends

.subckt sky130_fd_sc_hd__clkbuf_8 X A VGND VPWR VPB VNB
X0 VPWR A a_110_47# VPB sky130_fd_pr__pfet_01v8_hvt ad=0.14 pd=1.28 as=0.14 ps=1.28 w=1 l=0.15
X1 VPWR a_110_47# X VPB sky130_fd_pr__pfet_01v8_hvt ad=0.14 pd=1.28 as=0.14 ps=1.28 w=1 l=0.15
X2 X a_110_47# VPWR VPB sky130_fd_pr__pfet_01v8_hvt ad=0.14 pd=1.28 as=0.14 ps=1.28 w=1 l=0.15
X3 a_110_47# A VPWR VPB sky130_fd_pr__pfet_01v8_hvt ad=0.14 pd=1.28 as=0.265 ps=2.53 w=1 l=0.15
X4 X a_110_47# VGND VNB sky130_fd_pr__nfet_01v8 ad=0.0588 pd=0.7 as=0.0588 ps=0.7 w=0.42 l=0.15
X5 X a_110_47# VPWR VPB sky130_fd_pr__pfet_01v8_hvt ad=0.14 pd=1.28 as=0.14 ps=1.28 w=1 l=0.15
X6 VGND a_110_47# X VNB sky130_fd_pr__nfet_01v8 ad=0.0588 pd=0.7 as=0.0588 ps=0.7 w=0.42 l=0.15
X7 VPWR a_110_47# X VPB sky130_fd_pr__pfet_01v8_hvt ad=0.14 pd=1.28 as=0.14 ps=1.28 w=1 l=0.15
X8 VGND A a_110_47# VNB sky130_fd_pr__nfet_01v8 ad=0.0588 pd=0.7 as=0.0588 ps=0.7 w=0.42 l=0.15
X9 VGND a_110_47# X VNB sky130_fd_pr__nfet_01v8 ad=0.1134 pd=1.38 as=0.0588 ps=0.7 w=0.42 l=0.15
X10 a_110_47# A VGND VNB sky130_fd_pr__nfet_01v8 ad=0.0588 pd=0.7 as=0.1113 ps=1.37 w=0.42 l=0.15
X11 VPWR a_110_47# X VPB sky130_fd_pr__pfet_01v8_hvt ad=0.14 pd=1.28 as=0.14 ps=1.28 w=1 l=0.15
X12 X a_110_47# VPWR VPB sky130_fd_pr__pfet_01v8_hvt ad=0.14 pd=1.28 as=0.14 ps=1.28 w=1 l=0.15
X13 VGND a_110_47# X VNB sky130_fd_pr__nfet_01v8 ad=0.0588 pd=0.7 as=0.0588 ps=0.7 w=0.42 l=0.15
X14 VGND a_110_47# X VNB sky130_fd_pr__nfet_01v8 ad=0.0588 pd=0.7 as=0.0588 ps=0.7 w=0.42 l=0.15
X15 X a_110_47# VPWR VPB sky130_fd_pr__pfet_01v8_hvt ad=0.14 pd=1.28 as=0.14 ps=1.28 w=1 l=0.15
X16 X a_110_47# VGND VNB sky130_fd_pr__nfet_01v8 ad=0.0588 pd=0.7 as=0.0588 ps=0.7 w=0.42 l=0.15
X17 VPWR a_110_47# X VPB sky130_fd_pr__pfet_01v8_hvt ad=0.265 pd=2.53 as=0.14 ps=1.28 w=1 l=0.15
X18 X a_110_47# VGND VNB sky130_fd_pr__nfet_01v8 ad=0.0588 pd=0.7 as=0.0588 ps=0.7 w=0.42 l=0.15
X19 X a_110_47# VGND VNB sky130_fd_pr__nfet_01v8 ad=0.0588 pd=0.7 as=0.0588 ps=0.7 w=0.42 l=0.15
.ends

.subckt sky130_fd_sc_hd__nor3b_2 C_N Y A B VGND VPWR VPB VNB
X0 a_281_297# B a_27_297# VPB sky130_fd_pr__pfet_01v8_hvt ad=0.135 pd=1.27 as=0.135 ps=1.27 w=1 l=0.15
X1 Y B VGND VNB sky130_fd_pr__nfet_01v8 ad=0.08775 pd=0.92 as=0.08775 ps=0.92 w=0.65 l=0.15
X2 a_27_297# A VPWR VPB sky130_fd_pr__pfet_01v8_hvt ad=0.135 pd=1.27 as=0.135 ps=1.27 w=1 l=0.15
X3 VGND a_531_21# Y VNB sky130_fd_pr__nfet_01v8 ad=0.182 pd=1.86 as=0.08775 ps=0.92 w=0.65 l=0.15
X4 VPWR C_N a_531_21# VPB sky130_fd_pr__pfet_01v8_hvt ad=0.1092 pd=1.36 as=0.1092 ps=1.36 w=0.42 l=0.15
X5 VGND A Y VNB sky130_fd_pr__nfet_01v8 ad=0.08775 pd=0.92 as=0.08775 ps=0.92 w=0.65 l=0.15
X6 Y A VGND VNB sky130_fd_pr__nfet_01v8 ad=0.08775 pd=0.92 as=0.182 ps=1.86 w=0.65 l=0.15
X7 VGND B Y VNB sky130_fd_pr__nfet_01v8 ad=0.169 pd=1.82 as=0.08775 ps=0.92 w=0.65 l=0.15
X8 VPWR A a_27_297# VPB sky130_fd_pr__pfet_01v8_hvt ad=0.135 pd=1.27 as=0.28 ps=2.56 w=1 l=0.15
X9 a_281_297# a_531_21# Y VPB sky130_fd_pr__pfet_01v8_hvt ad=0.28 pd=2.56 as=0.135 ps=1.27 w=1 l=0.15
X10 Y a_531_21# a_281_297# VPB sky130_fd_pr__pfet_01v8_hvt ad=0.135 pd=1.27 as=0.28 ps=2.56 w=1 l=0.15
X11 VGND C_N a_531_21# VNB sky130_fd_pr__nfet_01v8 ad=0.1092 pd=1.36 as=0.1092 ps=1.36 w=0.42 l=0.15
X12 a_27_297# B a_281_297# VPB sky130_fd_pr__pfet_01v8_hvt ad=0.28 pd=2.56 as=0.135 ps=1.27 w=1 l=0.15
X13 Y a_531_21# VGND VNB sky130_fd_pr__nfet_01v8 ad=0.08775 pd=0.92 as=0.169 ps=1.82 w=0.65 l=0.15
.ends

.subckt sky130_fd_sc_hd__mux2_1 S A1 A0 X VGND VPWR VPB VNB
X0 VPWR a_505_21# a_535_374# VPB sky130_fd_pr__pfet_01v8_hvt ad=0.0693 pd=0.75 as=0.0441 ps=0.63 w=0.42 l=0.15
X1 a_505_21# S VPWR VPB sky130_fd_pr__pfet_01v8_hvt ad=0.1176 pd=1.4 as=0.0693 ps=0.75 w=0.42 l=0.15
X2 a_218_374# S VPWR VPB sky130_fd_pr__pfet_01v8_hvt ad=0.07665 pd=0.785 as=0.15835 ps=1.395 w=0.42 l=0.15
X3 VGND a_505_21# a_439_47# VNB sky130_fd_pr__nfet_01v8 ad=0.1449 pd=1.11 as=0.0693 ps=0.75 w=0.42 l=0.15
X4 a_76_199# A0 a_218_374# VPB sky130_fd_pr__pfet_01v8_hvt ad=0.1932 pd=1.34 as=0.07665 ps=0.785 w=0.42 l=0.15
X5 a_505_21# S VGND VNB sky130_fd_pr__nfet_01v8 ad=0.1092 pd=1.36 as=0.1449 ps=1.11 w=0.42 l=0.15
X6 a_439_47# A0 a_76_199# VNB sky130_fd_pr__nfet_01v8 ad=0.0693 pd=0.75 as=0.09975 ps=0.895 w=0.42 l=0.15
X7 a_535_374# A1 a_76_199# VPB sky130_fd_pr__pfet_01v8_hvt ad=0.0441 pd=0.63 as=0.1932 ps=1.34 w=0.42 l=0.15
X8 a_76_199# A1 a_218_47# VNB sky130_fd_pr__nfet_01v8 ad=0.09975 pd=0.895 as=0.0693 ps=0.75 w=0.42 l=0.15
X9 a_218_47# S VGND VNB sky130_fd_pr__nfet_01v8 ad=0.0693 pd=0.75 as=0.11285 ps=1.045 w=0.42 l=0.15
X10 VPWR a_76_199# X VPB sky130_fd_pr__pfet_01v8_hvt ad=0.15835 pd=1.395 as=0.26 ps=2.52 w=1 l=0.15
X11 VGND a_76_199# X VNB sky130_fd_pr__nfet_01v8 ad=0.11285 pd=1.045 as=0.169 ps=1.82 w=0.65 l=0.15
.ends

.subckt sky130_fd_sc_hd__a21o_2 X B1 A1 A2 VGND VPWR VPB VNB
X0 VPWR a_80_199# X VPB sky130_fd_pr__pfet_01v8_hvt ad=0.265 pd=2.53 as=0.14 ps=1.28 w=1 l=0.15
X1 X a_80_199# VPWR VPB sky130_fd_pr__pfet_01v8_hvt ad=0.14 pd=1.28 as=0.265 ps=2.53 w=1 l=0.15
X2 VGND a_80_199# X VNB sky130_fd_pr__nfet_01v8 ad=0.1105 pd=0.99 as=0.091 ps=0.93 w=0.65 l=0.15
X3 a_386_297# A2 VPWR VPB sky130_fd_pr__pfet_01v8_hvt ad=0.26 pd=2.52 as=0.1575 ps=1.315 w=1 l=0.15
X4 X a_80_199# VGND VNB sky130_fd_pr__nfet_01v8 ad=0.091 pd=0.93 as=0.17225 ps=1.83 w=0.65 l=0.15
X5 a_80_199# B1 VGND VNB sky130_fd_pr__nfet_01v8 ad=0.1625 pd=1.15 as=0.1105 ps=0.99 w=0.65 l=0.15
X6 a_386_297# B1 a_80_199# VPB sky130_fd_pr__pfet_01v8_hvt ad=0.14 pd=1.28 as=0.265 ps=2.53 w=1 l=0.15
X7 a_458_47# A1 a_80_199# VNB sky130_fd_pr__nfet_01v8 ad=0.1235 pd=1.03 as=0.1625 ps=1.15 w=0.65 l=0.15
X8 VPWR A1 a_386_297# VPB sky130_fd_pr__pfet_01v8_hvt ad=0.1575 pd=1.315 as=0.14 ps=1.28 w=1 l=0.15
X9 VGND A2 a_458_47# VNB sky130_fd_pr__nfet_01v8 ad=0.17225 pd=1.83 as=0.1235 ps=1.03 w=0.65 l=0.15
.ends

.subckt sky130_fd_sc_hd__a211oi_2 A2 C1 B1 Y A1 VPWR VGND VPB VNB
X0 VGND A2 a_485_47# VNB sky130_fd_pr__nfet_01v8 ad=0.091 pd=0.93 as=0.091 ps=0.93 w=0.65 l=0.15
X1 VPWR A1 a_292_297# VPB sky130_fd_pr__pfet_01v8_hvt ad=0.14 pd=1.28 as=0.14 ps=1.28 w=1 l=0.15
X2 a_37_297# B1 a_292_297# VPB sky130_fd_pr__pfet_01v8_hvt ad=0.265 pd=2.53 as=0.14 ps=1.28 w=1 l=0.15
X3 Y B1 VGND VNB sky130_fd_pr__nfet_01v8 ad=0.091 pd=0.93 as=0.091 ps=0.93 w=0.65 l=0.15
X4 a_485_47# A2 VGND VNB sky130_fd_pr__nfet_01v8 ad=0.17225 pd=1.83 as=0.091 ps=0.93 w=0.65 l=0.15
X5 a_292_297# A2 VPWR VPB sky130_fd_pr__pfet_01v8_hvt ad=0.14 pd=1.28 as=0.14 ps=1.28 w=1 l=0.15
X6 VGND B1 Y VNB sky130_fd_pr__nfet_01v8 ad=0.17225 pd=1.83 as=0.091 ps=0.93 w=0.65 l=0.15
X7 VPWR A2 a_292_297# VPB sky130_fd_pr__pfet_01v8_hvt ad=0.265 pd=2.53 as=0.14 ps=1.28 w=1 l=0.15
X8 a_485_47# A1 Y VNB sky130_fd_pr__nfet_01v8 ad=0.091 pd=0.93 as=0.091 ps=0.93 w=0.65 l=0.15
X9 VGND C1 Y VNB sky130_fd_pr__nfet_01v8 ad=0.091 pd=0.93 as=0.091 ps=0.93 w=0.65 l=0.15
X10 Y C1 VGND VNB sky130_fd_pr__nfet_01v8 ad=0.091 pd=0.93 as=0.17225 ps=1.83 w=0.65 l=0.15
X11 a_37_297# C1 Y VPB sky130_fd_pr__pfet_01v8_hvt ad=0.14 pd=1.28 as=0.14 ps=1.28 w=1 l=0.15
X12 Y A1 a_485_47# VNB sky130_fd_pr__nfet_01v8 ad=0.091 pd=0.93 as=0.17225 ps=1.83 w=0.65 l=0.15
X13 Y C1 a_37_297# VPB sky130_fd_pr__pfet_01v8_hvt ad=0.14 pd=1.28 as=0.265 ps=2.53 w=1 l=0.15
X14 a_292_297# A1 VPWR VPB sky130_fd_pr__pfet_01v8_hvt ad=0.14 pd=1.28 as=0.265 ps=2.53 w=1 l=0.15
X15 a_292_297# B1 a_37_297# VPB sky130_fd_pr__pfet_01v8_hvt ad=0.14 pd=1.28 as=0.14 ps=1.28 w=1 l=0.15
.ends

.subckt sky130_fd_sc_hd__a22oi_2 A1 A2 B1 B2 Y VPWR VGND VPB VNB
X0 a_109_297# A2 VPWR VPB sky130_fd_pr__pfet_01v8_hvt ad=0.26 pd=2.52 as=0.135 ps=1.27 w=1 l=0.15
X1 a_467_47# A1 Y VNB sky130_fd_pr__nfet_01v8 ad=0.08775 pd=0.92 as=0.08775 ps=0.92 w=0.65 l=0.15
X2 VPWR A2 a_109_297# VPB sky130_fd_pr__pfet_01v8_hvt ad=0.135 pd=1.27 as=0.135 ps=1.27 w=1 l=0.15
X3 a_467_47# A2 VGND VNB sky130_fd_pr__nfet_01v8 ad=0.169 pd=1.82 as=0.08775 ps=0.92 w=0.65 l=0.15
X4 Y B1 a_109_297# VPB sky130_fd_pr__pfet_01v8_hvt ad=0.26 pd=2.52 as=0.135 ps=1.27 w=1 l=0.15
X5 Y A1 a_467_47# VNB sky130_fd_pr__nfet_01v8 ad=0.08775 pd=0.92 as=0.169 ps=1.82 w=0.65 l=0.15
X6 a_109_297# B1 Y VPB sky130_fd_pr__pfet_01v8_hvt ad=0.135 pd=1.27 as=0.135 ps=1.27 w=1 l=0.15
X7 VGND A2 a_467_47# VNB sky130_fd_pr__nfet_01v8 ad=0.08775 pd=0.92 as=0.08775 ps=0.92 w=0.65 l=0.15
X8 Y B2 a_109_297# VPB sky130_fd_pr__pfet_01v8_hvt ad=0.135 pd=1.27 as=0.135 ps=1.27 w=1 l=0.15
X9 a_27_47# B2 VGND VNB sky130_fd_pr__nfet_01v8 ad=0.08775 pd=0.92 as=0.08775 ps=0.92 w=0.65 l=0.15
X10 a_27_47# B1 Y VNB sky130_fd_pr__nfet_01v8 ad=0.169 pd=1.82 as=0.08775 ps=0.92 w=0.65 l=0.15
X11 a_109_297# A1 VPWR VPB sky130_fd_pr__pfet_01v8_hvt ad=0.135 pd=1.27 as=0.135 ps=1.27 w=1 l=0.15
X12 VPWR A1 a_109_297# VPB sky130_fd_pr__pfet_01v8_hvt ad=0.135 pd=1.27 as=0.26 ps=2.52 w=1 l=0.15
X13 Y B1 a_27_47# VNB sky130_fd_pr__nfet_01v8 ad=0.08775 pd=0.92 as=0.08775 ps=0.92 w=0.65 l=0.15
X14 a_109_297# B2 Y VPB sky130_fd_pr__pfet_01v8_hvt ad=0.135 pd=1.27 as=0.26 ps=2.52 w=1 l=0.15
X15 VGND B2 a_27_47# VNB sky130_fd_pr__nfet_01v8 ad=0.08775 pd=0.92 as=0.169 ps=1.82 w=0.65 l=0.15
.ends

.subckt sky130_fd_sc_hd__o221a_2 B2 A2 X B1 C1 A1 VGND VPWR VPB VNB
X0 VPWR a_38_47# X VPB sky130_fd_pr__pfet_01v8_hvt ad=0.26 pd=2.52 as=0.135 ps=1.27 w=1 l=0.15
X1 VPWR A1 a_497_297# VPB sky130_fd_pr__pfet_01v8_hvt ad=0.165 pd=1.33 as=0.105 ps=1.21 w=1 l=0.15
X2 X a_38_47# VPWR VPB sky130_fd_pr__pfet_01v8_hvt ad=0.135 pd=1.27 as=0.165 ps=1.33 w=1 l=0.15
X3 a_141_47# B2 a_225_47# VNB sky130_fd_pr__nfet_01v8 ad=0.169 pd=1.82 as=0.08775 ps=0.92 w=0.65 l=0.15
X4 a_497_297# A2 a_38_47# VPB sky130_fd_pr__pfet_01v8_hvt ad=0.105 pd=1.21 as=0.3875 ps=1.775 w=1 l=0.15
X5 VGND A1 a_225_47# VNB sky130_fd_pr__nfet_01v8 ad=0.08775 pd=0.92 as=0.08775 ps=0.92 w=0.65 l=0.15
X6 VPWR C1 a_38_47# VPB sky130_fd_pr__pfet_01v8_hvt ad=0.165 pd=1.33 as=0.325 ps=2.65 w=1 l=0.15
X7 a_237_297# B1 VPWR VPB sky130_fd_pr__pfet_01v8_hvt ad=0.1125 pd=1.225 as=0.165 ps=1.33 w=1 l=0.15
X8 a_38_47# B2 a_237_297# VPB sky130_fd_pr__pfet_01v8_hvt ad=0.3875 pd=1.775 as=0.1125 ps=1.225 w=1 l=0.15
X9 a_225_47# A2 VGND VNB sky130_fd_pr__nfet_01v8 ad=0.08775 pd=0.92 as=0.169 ps=1.82 w=0.65 l=0.15
X10 X a_38_47# VGND VNB sky130_fd_pr__nfet_01v8 ad=0.08775 pd=0.92 as=0.08775 ps=0.92 w=0.65 l=0.15
X11 a_141_47# C1 a_38_47# VNB sky130_fd_pr__nfet_01v8 ad=0.08775 pd=0.92 as=0.23725 ps=2.03 w=0.65 l=0.15
X12 VGND a_38_47# X VNB sky130_fd_pr__nfet_01v8 ad=0.169 pd=1.82 as=0.08775 ps=0.92 w=0.65 l=0.15
X13 a_225_47# B1 a_141_47# VNB sky130_fd_pr__nfet_01v8 ad=0.08775 pd=0.92 as=0.08775 ps=0.92 w=0.65 l=0.15
.ends

.subckt sky130_fd_sc_hd__and4_2 X C A B D VGND VPWR VPB VNB
X0 VGND a_27_47# X VNB sky130_fd_pr__nfet_01v8 ad=0.195 pd=1.9 as=0.10725 ps=0.98 w=0.65 l=0.15
X1 VGND D a_304_47# VNB sky130_fd_pr__nfet_01v8 ad=0.17515 pd=1.265 as=0.0693 ps=0.75 w=0.42 l=0.15
X2 X a_27_47# VPWR VPB sky130_fd_pr__pfet_01v8_hvt ad=0.165 pd=1.33 as=0.27995 ps=1.615 w=1 l=0.15
X3 a_198_47# B a_109_47# VNB sky130_fd_pr__nfet_01v8 ad=0.0798 pd=0.8 as=0.06195 ps=0.715 w=0.42 l=0.15
X4 a_27_47# C VPWR VPB sky130_fd_pr__pfet_01v8_hvt ad=0.0588 pd=0.7 as=0.0777 ps=0.79 w=0.42 l=0.15
X5 VPWR a_27_47# X VPB sky130_fd_pr__pfet_01v8_hvt ad=0.3 pd=2.6 as=0.165 ps=1.33 w=1 l=0.15
X6 a_304_47# C a_198_47# VNB sky130_fd_pr__nfet_01v8 ad=0.0693 pd=0.75 as=0.0798 ps=0.8 w=0.42 l=0.15
X7 a_27_47# A VPWR VPB sky130_fd_pr__pfet_01v8_hvt ad=0.07455 pd=0.775 as=0.1092 ps=1.36 w=0.42 l=0.15
X8 VPWR D a_27_47# VPB sky130_fd_pr__pfet_01v8_hvt ad=0.27995 pd=1.615 as=0.0588 ps=0.7 w=0.42 l=0.15
X9 X a_27_47# VGND VNB sky130_fd_pr__nfet_01v8 ad=0.10725 pd=0.98 as=0.17515 ps=1.265 w=0.65 l=0.15
X10 VPWR B a_27_47# VPB sky130_fd_pr__pfet_01v8_hvt ad=0.0777 pd=0.79 as=0.07455 ps=0.775 w=0.42 l=0.15
X11 a_109_47# A a_27_47# VNB sky130_fd_pr__nfet_01v8 ad=0.06195 pd=0.715 as=0.1092 ps=1.36 w=0.42 l=0.15
.ends

.subckt sky130_fd_sc_hd__a21oi_2 B1 A2 A1 Y VGND VPWR VPB VNB
X0 VGND A2 a_285_47# VNB sky130_fd_pr__nfet_01v8 ad=0.10725 pd=0.98 as=0.06825 ps=0.86 w=0.65 l=0.15
X1 VGND B1 Y VNB sky130_fd_pr__nfet_01v8 ad=0.26 pd=2.1 as=0.08775 ps=0.92 w=0.65 l=0.15
X2 Y A1 a_114_47# VNB sky130_fd_pr__nfet_01v8 ad=0.091 pd=0.93 as=0.089375 ps=0.925 w=0.65 l=0.15
X3 a_114_47# A2 VGND VNB sky130_fd_pr__nfet_01v8 ad=0.089375 pd=0.925 as=0.18525 ps=1.87 w=0.65 l=0.15
X4 a_27_297# B1 Y VPB sky130_fd_pr__pfet_01v8_hvt ad=0.36 pd=2.72 as=0.135 ps=1.27 w=1 l=0.15
X5 a_27_297# A1 VPWR VPB sky130_fd_pr__pfet_01v8_hvt ad=0.14 pd=1.28 as=0.14 ps=1.28 w=1 l=0.15
X6 Y B1 a_27_297# VPB sky130_fd_pr__pfet_01v8_hvt ad=0.135 pd=1.27 as=0.135 ps=1.27 w=1 l=0.15
X7 VPWR A2 a_27_297# VPB sky130_fd_pr__pfet_01v8_hvt ad=0.14 pd=1.28 as=0.28 ps=2.56 w=1 l=0.15
X8 a_27_297# A2 VPWR VPB sky130_fd_pr__pfet_01v8_hvt ad=0.135 pd=1.27 as=0.135 ps=1.27 w=1 l=0.15
X9 VPWR A1 a_27_297# VPB sky130_fd_pr__pfet_01v8_hvt ad=0.135 pd=1.27 as=0.14 ps=1.28 w=1 l=0.15
X10 a_285_47# A1 Y VNB sky130_fd_pr__nfet_01v8 ad=0.06825 pd=0.86 as=0.091 ps=0.93 w=0.65 l=0.15
X11 Y B1 VGND VNB sky130_fd_pr__nfet_01v8 ad=0.08775 pd=0.92 as=0.10725 ps=0.98 w=0.65 l=0.15
.ends

.subckt sky130_fd_sc_hd__o211a_2 C1 B1 A2 A1 X VPWR VGND VPB VNB
X0 a_27_47# B1 VPWR VPB sky130_fd_pr__pfet_01v8_hvt ad=0.3675 pd=1.735 as=0.14 ps=1.28 w=1 l=0.15
X1 VGND a_27_47# X VNB sky130_fd_pr__nfet_01v8 ad=0.23075 pd=2.01 as=0.091 ps=0.93 w=0.65 l=0.15
X2 VPWR C1 a_27_47# VPB sky130_fd_pr__pfet_01v8_hvt ad=0.14 pd=1.28 as=0.265 ps=2.53 w=1 l=0.15
X3 VPWR A1 a_373_297# VPB sky130_fd_pr__pfet_01v8_hvt ad=0.195 pd=1.39 as=0.105 ps=1.21 w=1 l=0.15
X4 a_182_47# A2 VGND VNB sky130_fd_pr__nfet_01v8 ad=0.091 pd=0.93 as=0.16535 ps=1.82 w=0.65 l=0.15
X5 X a_27_47# VPWR VPB sky130_fd_pr__pfet_01v8_hvt ad=0.14 pd=1.28 as=0.195 ps=1.39 w=1 l=0.15
X6 a_182_47# B1 a_110_47# VNB sky130_fd_pr__nfet_01v8 ad=0.16535 pd=1.82 as=0.06825 ps=0.86 w=0.65 l=0.15
X7 X a_27_47# VGND VNB sky130_fd_pr__nfet_01v8 ad=0.091 pd=0.93 as=0.104 ps=0.97 w=0.65 l=0.15
X8 a_373_297# A2 a_27_47# VPB sky130_fd_pr__pfet_01v8_hvt ad=0.105 pd=1.21 as=0.3675 ps=1.735 w=1 l=0.15
X9 a_110_47# C1 a_27_47# VNB sky130_fd_pr__nfet_01v8 ad=0.06825 pd=0.86 as=0.17225 ps=1.83 w=0.65 l=0.15
X10 VPWR a_27_47# X VPB sky130_fd_pr__pfet_01v8_hvt ad=0.265 pd=2.53 as=0.14 ps=1.28 w=1 l=0.15
X11 VGND A1 a_182_47# VNB sky130_fd_pr__nfet_01v8 ad=0.104 pd=0.97 as=0.091 ps=0.93 w=0.65 l=0.15
.ends

.subckt sky130_fd_sc_hd__or4b_2 C A X B D_N VPWR VGND VPB VNB
X0 a_176_21# C VGND VNB sky130_fd_pr__nfet_01v8 ad=0.0567 pd=0.69 as=0.0567 ps=0.69 w=0.42 l=0.15
X1 VGND D_N a_27_53# VNB sky130_fd_pr__nfet_01v8 ad=0.10025 pd=0.985 as=0.1092 ps=1.36 w=0.42 l=0.15
X2 VGND a_176_21# X VNB sky130_fd_pr__nfet_01v8 ad=0.10025 pd=0.985 as=0.08775 ps=0.92 w=0.65 l=0.15
X3 X a_176_21# VGND VNB sky130_fd_pr__nfet_01v8 ad=0.08775 pd=0.92 as=0.10025 ps=0.985 w=0.65 l=0.15
X4 VPWR a_176_21# X VPB sky130_fd_pr__pfet_01v8_hvt ad=0.16835 pd=1.495 as=0.135 ps=1.27 w=1 l=0.15
X5 a_555_297# C a_483_297# VPB sky130_fd_pr__pfet_01v8_hvt ad=0.0693 pd=0.75 as=0.0441 ps=0.63 w=0.42 l=0.15
X6 a_176_21# a_27_53# a_555_297# VPB sky130_fd_pr__pfet_01v8_hvt ad=0.1092 pd=1.36 as=0.0693 ps=0.75 w=0.42 l=0.15
X7 X a_176_21# VPWR VPB sky130_fd_pr__pfet_01v8_hvt ad=0.135 pd=1.27 as=0.1693 ps=1.5 w=1 l=0.15
X8 a_387_297# A VPWR VPB sky130_fd_pr__pfet_01v8_hvt ad=0.0693 pd=0.75 as=0.16835 ps=1.495 w=0.42 l=0.15
X9 a_483_297# B a_387_297# VPB sky130_fd_pr__pfet_01v8_hvt ad=0.0441 pd=0.63 as=0.0693 ps=0.75 w=0.42 l=0.15
X10 VGND B a_176_21# VNB sky130_fd_pr__nfet_01v8 ad=0.0567 pd=0.69 as=0.0693 ps=0.75 w=0.42 l=0.15
X11 VGND a_27_53# a_176_21# VNB sky130_fd_pr__nfet_01v8 ad=0.1092 pd=1.36 as=0.0567 ps=0.69 w=0.42 l=0.15
X12 VPWR D_N a_27_53# VPB sky130_fd_pr__pfet_01v8_hvt ad=0.1693 pd=1.5 as=0.1092 ps=1.36 w=0.42 l=0.15
X13 a_176_21# A VGND VNB sky130_fd_pr__nfet_01v8 ad=0.0693 pd=0.75 as=0.10025 ps=0.985 w=0.42 l=0.15
.ends

.subckt sky130_fd_sc_hd__dfrtp_2 Q RESET_B D CLK VGND VPWR VPB VNB
X0 a_805_47# a_761_289# a_639_47# VNB sky130_fd_pr__nfet_01v8 ad=0.0441 pd=0.63 as=0.1401 ps=1.1 w=0.42 l=0.15
X1 a_1217_47# a_27_47# a_1108_47# VNB sky130_fd_pr__special_nfet_01v8 ad=0.0669 pd=0.75 as=0.0711 ps=0.755 w=0.36 l=0.15
X2 VGND a_1283_21# Q VNB sky130_fd_pr__nfet_01v8 ad=0.169 pd=1.82 as=0.08775 ps=0.92 w=0.65 l=0.15
X3 a_1283_21# a_1108_47# a_1462_47# VNB sky130_fd_pr__nfet_01v8 ad=0.1092 pd=1.36 as=0.06405 ps=0.725 w=0.42 l=0.15
X4 a_651_413# a_27_47# a_543_47# VPB sky130_fd_pr__pfet_01v8_hvt ad=0.1155 pd=0.97 as=0.07245 ps=0.765 w=0.42 l=0.15
X5 VPWR a_1283_21# Q VPB sky130_fd_pr__pfet_01v8_hvt ad=0.26 pd=2.52 as=0.135 ps=1.27 w=1 l=0.15
X6 a_1108_47# a_193_47# a_761_289# VNB sky130_fd_pr__special_nfet_01v8 ad=0.0711 pd=0.755 as=0.0999 ps=0.985 w=0.36 l=0.15
X7 VGND RESET_B a_805_47# VNB sky130_fd_pr__nfet_01v8 ad=0.1346 pd=1.15 as=0.0441 ps=0.63 w=0.42 l=0.15
X8 Q a_1283_21# VPWR VPB sky130_fd_pr__pfet_01v8_hvt ad=0.135 pd=1.27 as=0.3012 ps=2.66 w=1 l=0.15
X9 VPWR CLK a_27_47# VPB sky130_fd_pr__pfet_01v8_hvt ad=0.0864 pd=0.91 as=0.1664 ps=1.8 w=0.64 l=0.15
X10 a_448_47# D VPWR VPB sky130_fd_pr__pfet_01v8_hvt ad=0.0651 pd=0.73 as=0.1092 ps=1.36 w=0.42 l=0.15
X11 a_761_289# a_543_47# VGND VNB sky130_fd_pr__nfet_01v8 ad=0.0999 pd=0.985 as=0.1346 ps=1.15 w=0.64 l=0.15
X12 a_193_47# a_27_47# VGND VNB sky130_fd_pr__nfet_01v8 ad=0.1092 pd=1.36 as=0.0567 ps=0.69 w=0.42 l=0.15
X13 a_1108_47# a_27_47# a_761_289# VPB sky130_fd_pr__pfet_01v8_hvt ad=0.0588 pd=0.7 as=0.12915 ps=1.185 w=0.42 l=0.15
X14 a_1462_47# RESET_B VGND VNB sky130_fd_pr__nfet_01v8 ad=0.06405 pd=0.725 as=0.12495 ps=1.015 w=0.42 l=0.15
X15 a_543_47# a_27_47# a_448_47# VNB sky130_fd_pr__special_nfet_01v8 ad=0.0594 pd=0.69 as=0.066 ps=0.745 w=0.36 l=0.15
X16 a_543_47# a_193_47# a_448_47# VPB sky130_fd_pr__pfet_01v8_hvt ad=0.07245 pd=0.765 as=0.0651 ps=0.73 w=0.42 l=0.15
X17 a_448_47# D VGND VNB sky130_fd_pr__nfet_01v8 ad=0.066 pd=0.745 as=0.2205 ps=1.89 w=0.42 l=0.15
X18 VPWR a_1283_21# a_1270_413# VPB sky130_fd_pr__pfet_01v8_hvt ad=0.0819 pd=0.81 as=0.0567 ps=0.69 w=0.42 l=0.15
X19 VPWR a_1108_47# a_1283_21# VPB sky130_fd_pr__pfet_01v8_hvt ad=0.1134 pd=1.38 as=0.0567 ps=0.69 w=0.42 l=0.15
X20 a_1270_413# a_193_47# a_1108_47# VPB sky130_fd_pr__pfet_01v8_hvt ad=0.0567 pd=0.69 as=0.0588 ps=0.7 w=0.42 l=0.15
X21 a_193_47# a_27_47# VPWR VPB sky130_fd_pr__pfet_01v8_hvt ad=0.1664 pd=1.8 as=0.0864 ps=0.91 w=0.64 l=0.15
X22 a_1283_21# RESET_B VPWR VPB sky130_fd_pr__pfet_01v8_hvt ad=0.0567 pd=0.69 as=0.0819 ps=0.81 w=0.42 l=0.15
X23 VPWR a_761_289# a_651_413# VPB sky130_fd_pr__pfet_01v8_hvt ad=0.07035 pd=0.755 as=0.1155 ps=0.97 w=0.42 l=0.15
X24 Q a_1283_21# VGND VNB sky130_fd_pr__nfet_01v8 ad=0.08775 pd=0.92 as=0.2087 ps=2.02 w=0.65 l=0.15
X25 a_639_47# a_193_47# a_543_47# VNB sky130_fd_pr__special_nfet_01v8 ad=0.1401 pd=1.1 as=0.0594 ps=0.69 w=0.36 l=0.15
X26 VGND a_1283_21# a_1217_47# VNB sky130_fd_pr__nfet_01v8 ad=0.12495 pd=1.015 as=0.0669 ps=0.75 w=0.42 l=0.15
X27 a_651_413# RESET_B VPWR VPB sky130_fd_pr__pfet_01v8_hvt ad=0.1092 pd=1.36 as=0.07035 ps=0.755 w=0.42 l=0.15
X28 VGND CLK a_27_47# VNB sky130_fd_pr__nfet_01v8 ad=0.0567 pd=0.69 as=0.1092 ps=1.36 w=0.42 l=0.15
X29 a_761_289# a_543_47# VPWR VPB sky130_fd_pr__pfet_01v8_hvt ad=0.12915 pd=1.185 as=0.2184 ps=2.2 w=0.84 l=0.15
.ends

.subckt sky130_fd_sc_hd__o2bb2a_2 A1_N X A2_N B2 B1 VGND VPWR VPB VNB
X0 a_294_47# A1_N VGND VNB sky130_fd_pr__nfet_01v8 ad=0.06615 pd=0.735 as=0.098625 ps=0.98 w=0.42 l=0.15
X1 VPWR A2_N a_295_369# VPB sky130_fd_pr__pfet_01v8_hvt ad=0.2272 pd=1.35 as=0.173 ps=1.4 w=0.64 l=0.15
X2 VPWR B1 a_665_369# VPB sky130_fd_pr__pfet_01v8_hvt ad=0.1664 pd=1.8 as=0.0864 ps=0.91 w=0.64 l=0.15
X3 VGND a_84_21# X VNB sky130_fd_pr__nfet_01v8 ad=0.098625 pd=0.98 as=0.08775 ps=0.92 w=0.65 l=0.15
X4 X a_84_21# VGND VNB sky130_fd_pr__nfet_01v8 ad=0.08775 pd=0.92 as=0.18525 ps=1.87 w=0.65 l=0.15
X5 a_581_47# a_295_369# a_84_21# VNB sky130_fd_pr__nfet_01v8 ad=0.0567 pd=0.69 as=0.1092 ps=1.36 w=0.42 l=0.15
X6 VPWR a_84_21# X VPB sky130_fd_pr__pfet_01v8_hvt ad=0.154 pd=1.335 as=0.135 ps=1.27 w=1 l=0.15
X7 a_665_369# B2 a_84_21# VPB sky130_fd_pr__pfet_01v8_hvt ad=0.0864 pd=0.91 as=0.0928 ps=0.93 w=0.64 l=0.15
X8 VGND B2 a_581_47# VNB sky130_fd_pr__nfet_01v8 ad=0.0567 pd=0.69 as=0.0567 ps=0.69 w=0.42 l=0.15
X9 a_295_369# A2_N a_294_47# VNB sky130_fd_pr__nfet_01v8 ad=0.1092 pd=1.36 as=0.06615 ps=0.735 w=0.42 l=0.15
X10 X a_84_21# VPWR VPB sky130_fd_pr__pfet_01v8_hvt ad=0.135 pd=1.27 as=0.285 ps=2.57 w=1 l=0.15
X11 a_84_21# a_295_369# VPWR VPB sky130_fd_pr__pfet_01v8_hvt ad=0.0928 pd=0.93 as=0.2272 ps=1.35 w=0.64 l=0.15
X12 a_295_369# A1_N VPWR VPB sky130_fd_pr__pfet_01v8_hvt ad=0.173 pd=1.4 as=0.154 ps=1.335 w=0.64 l=0.15
X13 a_581_47# B1 VGND VNB sky130_fd_pr__nfet_01v8 ad=0.1092 pd=1.36 as=0.0567 ps=0.69 w=0.42 l=0.15
.ends

.subckt sky130_fd_sc_hd__xor2_2 X B A VPWR VGND VPB VNB
X0 a_27_297# A VPWR VPB sky130_fd_pr__pfet_01v8_hvt ad=0.135 pd=1.27 as=0.135 ps=1.27 w=1 l=0.15
X1 a_470_47# A VGND VNB sky130_fd_pr__nfet_01v8 ad=0.08775 pd=0.92 as=0.08775 ps=0.92 w=0.65 l=0.15
X2 a_470_297# A VPWR VPB sky130_fd_pr__pfet_01v8_hvt ad=0.135 pd=1.27 as=0.135 ps=1.27 w=1 l=0.15
X3 VPWR A a_470_297# VPB sky130_fd_pr__pfet_01v8_hvt ad=0.135 pd=1.27 as=0.26 ps=2.52 w=1 l=0.15
X4 a_112_47# B VGND VNB sky130_fd_pr__nfet_01v8 ad=0.08775 pd=0.92 as=0.08775 ps=0.92 w=0.65 l=0.15
X5 a_470_47# B X VNB sky130_fd_pr__nfet_01v8 ad=0.169 pd=1.82 as=0.105625 ps=0.975 w=0.65 l=0.15
X6 VGND A a_112_47# VNB sky130_fd_pr__nfet_01v8 ad=0.08775 pd=0.92 as=0.08775 ps=0.92 w=0.65 l=0.15
X7 a_112_47# A VGND VNB sky130_fd_pr__nfet_01v8 ad=0.08775 pd=0.92 as=0.17875 ps=1.85 w=0.65 l=0.15
X8 VGND B a_112_47# VNB sky130_fd_pr__nfet_01v8 ad=0.169 pd=1.82 as=0.08775 ps=0.92 w=0.65 l=0.15
X9 VPWR A a_27_297# VPB sky130_fd_pr__pfet_01v8_hvt ad=0.135 pd=1.27 as=0.275 ps=2.55 w=1 l=0.15
X10 a_470_297# B VPWR VPB sky130_fd_pr__pfet_01v8_hvt ad=0.26 pd=2.52 as=0.1625 ps=1.325 w=1 l=0.15
X11 X a_112_47# VGND VNB sky130_fd_pr__nfet_01v8 ad=0.08775 pd=0.92 as=0.169 ps=1.82 w=0.65 l=0.15
X12 VPWR B a_470_297# VPB sky130_fd_pr__pfet_01v8_hvt ad=0.1625 pd=1.325 as=0.135 ps=1.27 w=1 l=0.15
X13 VGND a_112_47# X VNB sky130_fd_pr__nfet_01v8 ad=0.169 pd=1.82 as=0.08775 ps=0.92 w=0.65 l=0.15
X14 VGND A a_470_47# VNB sky130_fd_pr__nfet_01v8 ad=0.08775 pd=0.92 as=0.169 ps=1.82 w=0.65 l=0.15
X15 a_27_297# B a_112_47# VPB sky130_fd_pr__pfet_01v8_hvt ad=0.26 pd=2.52 as=0.135 ps=1.27 w=1 l=0.15
X16 X a_112_47# a_470_297# VPB sky130_fd_pr__pfet_01v8_hvt ad=0.135 pd=1.27 as=0.26 ps=2.52 w=1 l=0.15
X17 a_470_297# a_112_47# X VPB sky130_fd_pr__pfet_01v8_hvt ad=0.28 pd=2.56 as=0.135 ps=1.27 w=1 l=0.15
X18 X B a_470_47# VNB sky130_fd_pr__nfet_01v8 ad=0.105625 pd=0.975 as=0.08775 ps=0.92 w=0.65 l=0.15
X19 a_112_47# B a_27_297# VPB sky130_fd_pr__pfet_01v8_hvt ad=0.135 pd=1.27 as=0.135 ps=1.27 w=1 l=0.15
.ends

.subckt sky130_fd_sc_hd__nand2b_2 B Y A_N VGND VPWR VPB VNB
X0 Y B VPWR VPB sky130_fd_pr__pfet_01v8_hvt ad=0.135 pd=1.27 as=0.335 ps=1.67 w=1 l=0.15
X1 VGND A_N a_27_93# VNB sky130_fd_pr__nfet_01v8 ad=0.194 pd=1.95 as=0.1092 ps=1.36 w=0.42 l=0.15
X2 VGND B a_229_47# VNB sky130_fd_pr__nfet_01v8 ad=0.08775 pd=0.92 as=0.08775 ps=0.92 w=0.65 l=0.15
X3 Y a_27_93# a_229_47# VNB sky130_fd_pr__nfet_01v8 ad=0.08775 pd=0.92 as=0.169 ps=1.82 w=0.65 l=0.15
X4 a_229_47# a_27_93# Y VNB sky130_fd_pr__nfet_01v8 ad=0.08775 pd=0.92 as=0.08775 ps=0.92 w=0.65 l=0.15
X5 Y a_27_93# VPWR VPB sky130_fd_pr__pfet_01v8_hvt ad=0.165 pd=1.33 as=0.1468 ps=1.34 w=1 l=0.15
X6 VPWR a_27_93# Y VPB sky130_fd_pr__pfet_01v8_hvt ad=0.335 pd=1.67 as=0.165 ps=1.33 w=1 l=0.15
X7 VPWR B Y VPB sky130_fd_pr__pfet_01v8_hvt ad=0.275 pd=2.55 as=0.135 ps=1.27 w=1 l=0.15
X8 a_229_47# B VGND VNB sky130_fd_pr__nfet_01v8 ad=0.169 pd=1.82 as=0.08775 ps=0.92 w=0.65 l=0.15
X9 VPWR A_N a_27_93# VPB sky130_fd_pr__pfet_01v8_hvt ad=0.1468 pd=1.34 as=0.1092 ps=1.36 w=0.42 l=0.15
.ends

.subckt sky130_fd_sc_hd__o211ai_2 A1 A2 B1 Y C1 VGND VPWR VPB VNB
X0 a_286_47# A1 VGND VNB sky130_fd_pr__nfet_01v8 ad=0.091 pd=0.93 as=0.091 ps=0.93 w=0.65 l=0.15
X1 VPWR B1 Y VPB sky130_fd_pr__pfet_01v8_hvt ad=0.265 pd=2.53 as=0.14 ps=1.28 w=1 l=0.15
X2 a_286_47# A2 VGND VNB sky130_fd_pr__nfet_01v8 ad=0.091 pd=0.93 as=0.18525 ps=1.87 w=0.65 l=0.15
X3 Y A2 a_487_297# VPB sky130_fd_pr__pfet_01v8_hvt ad=0.14 pd=1.28 as=0.265 ps=2.53 w=1 l=0.15
X4 VGND A1 a_286_47# VNB sky130_fd_pr__nfet_01v8 ad=0.18525 pd=1.87 as=0.091 ps=0.93 w=0.65 l=0.15
X5 Y C1 a_27_47# VNB sky130_fd_pr__nfet_01v8 ad=0.091 pd=0.93 as=0.18525 ps=1.87 w=0.65 l=0.15
X6 VGND A2 a_286_47# VNB sky130_fd_pr__nfet_01v8 ad=0.091 pd=0.93 as=0.091 ps=0.93 w=0.65 l=0.15
X7 a_487_297# A2 Y VPB sky130_fd_pr__pfet_01v8_hvt ad=0.14 pd=1.28 as=0.14 ps=1.28 w=1 l=0.15
X8 a_27_47# B1 a_286_47# VNB sky130_fd_pr__nfet_01v8 ad=0.18525 pd=1.87 as=0.091 ps=0.93 w=0.65 l=0.15
X9 VPWR C1 Y VPB sky130_fd_pr__pfet_01v8_hvt ad=0.14 pd=1.28 as=0.14 ps=1.28 w=1 l=0.15
X10 VPWR A1 a_487_297# VPB sky130_fd_pr__pfet_01v8_hvt ad=0.14 pd=1.28 as=0.14 ps=1.28 w=1 l=0.15
X11 a_27_47# C1 Y VNB sky130_fd_pr__nfet_01v8 ad=0.091 pd=0.93 as=0.091 ps=0.93 w=0.65 l=0.15
X12 Y C1 VPWR VPB sky130_fd_pr__pfet_01v8_hvt ad=0.14 pd=1.28 as=0.265 ps=2.53 w=1 l=0.15
X13 a_487_297# A1 VPWR VPB sky130_fd_pr__pfet_01v8_hvt ad=0.265 pd=2.53 as=0.14 ps=1.28 w=1 l=0.15
X14 a_286_47# B1 a_27_47# VNB sky130_fd_pr__nfet_01v8 ad=0.091 pd=0.93 as=0.091 ps=0.93 w=0.65 l=0.15
X15 Y B1 VPWR VPB sky130_fd_pr__pfet_01v8_hvt ad=0.14 pd=1.28 as=0.14 ps=1.28 w=1 l=0.15
.ends

.subckt sky130_fd_sc_hd__or4_2 C A X B D VPWR VGND VPB VNB
X0 a_27_297# B VGND VNB sky130_fd_pr__nfet_01v8 ad=0.0567 pd=0.69 as=0.0567 ps=0.69 w=0.42 l=0.15
X1 a_27_297# D VGND VNB sky130_fd_pr__nfet_01v8 ad=0.0693 pd=0.75 as=0.1092 ps=1.36 w=0.42 l=0.15
X2 a_277_297# B a_205_297# VPB sky130_fd_pr__pfet_01v8_hvt ad=0.0693 pd=0.75 as=0.0441 ps=0.63 w=0.42 l=0.15
X3 VPWR A a_277_297# VPB sky130_fd_pr__pfet_01v8_hvt ad=0.14825 pd=1.34 as=0.0693 ps=0.75 w=0.42 l=0.15
X4 X a_27_297# VGND VNB sky130_fd_pr__nfet_01v8 ad=0.08775 pd=0.92 as=0.101875 ps=0.99 w=0.65 l=0.15
X5 a_205_297# C a_109_297# VPB sky130_fd_pr__pfet_01v8_hvt ad=0.0441 pd=0.63 as=0.0693 ps=0.75 w=0.42 l=0.15
X6 VPWR a_27_297# X VPB sky130_fd_pr__pfet_01v8_hvt ad=0.305 pd=2.61 as=0.135 ps=1.27 w=1 l=0.15
X7 VGND a_27_297# X VNB sky130_fd_pr__nfet_01v8 ad=0.19825 pd=1.91 as=0.08775 ps=0.92 w=0.65 l=0.15
X8 X a_27_297# VPWR VPB sky130_fd_pr__pfet_01v8_hvt ad=0.135 pd=1.27 as=0.14825 ps=1.34 w=1 l=0.15
X9 VGND C a_27_297# VNB sky130_fd_pr__nfet_01v8 ad=0.0567 pd=0.69 as=0.0693 ps=0.75 w=0.42 l=0.15
X10 a_109_297# D a_27_297# VPB sky130_fd_pr__pfet_01v8_hvt ad=0.0693 pd=0.75 as=0.1092 ps=1.36 w=0.42 l=0.15
X11 VGND A a_27_297# VNB sky130_fd_pr__nfet_01v8 ad=0.101875 pd=0.99 as=0.0567 ps=0.69 w=0.42 l=0.15
.ends

.subckt sky130_fd_sc_hd__clkbuf_4 X A VGND VPWR VPB VNB
X0 VPWR A a_27_47# VPB sky130_fd_pr__pfet_01v8_hvt ad=0.165 pd=1.33 as=0.265 ps=2.53 w=1 l=0.15
X1 VGND a_27_47# X VNB sky130_fd_pr__nfet_01v8 ad=0.1218 pd=1.42 as=0.0588 ps=0.7 w=0.42 l=0.15
X2 VGND a_27_47# X VNB sky130_fd_pr__nfet_01v8 ad=0.0588 pd=0.7 as=0.0588 ps=0.7 w=0.42 l=0.15
X3 X a_27_47# VPWR VPB sky130_fd_pr__pfet_01v8_hvt ad=0.14 pd=1.28 as=0.14 ps=1.28 w=1 l=0.15
X4 X a_27_47# VGND VNB sky130_fd_pr__nfet_01v8 ad=0.0588 pd=0.7 as=0.0588 ps=0.7 w=0.42 l=0.15
X5 VGND A a_27_47# VNB sky130_fd_pr__nfet_01v8 ad=0.07035 pd=0.755 as=0.1113 ps=1.37 w=0.42 l=0.15
X6 VPWR a_27_47# X VPB sky130_fd_pr__pfet_01v8_hvt ad=0.3 pd=2.6 as=0.14 ps=1.28 w=1 l=0.15
X7 X a_27_47# VGND VNB sky130_fd_pr__nfet_01v8 ad=0.0588 pd=0.7 as=0.07035 ps=0.755 w=0.42 l=0.15
X8 X a_27_47# VPWR VPB sky130_fd_pr__pfet_01v8_hvt ad=0.14 pd=1.28 as=0.165 ps=1.33 w=1 l=0.15
X9 VPWR a_27_47# X VPB sky130_fd_pr__pfet_01v8_hvt ad=0.14 pd=1.28 as=0.14 ps=1.28 w=1 l=0.15
.ends

.subckt sky130_fd_sc_hd__inv_2 A Y VPWR VGND VPB VNB
X0 Y A VPWR VPB sky130_fd_pr__pfet_01v8_hvt ad=0.135 pd=1.27 as=0.26 ps=2.52 w=1 l=0.15
X1 VGND A Y VNB sky130_fd_pr__nfet_01v8 ad=0.169 pd=1.82 as=0.08775 ps=0.92 w=0.65 l=0.15
X2 Y A VGND VNB sky130_fd_pr__nfet_01v8 ad=0.08775 pd=0.92 as=0.169 ps=1.82 w=0.65 l=0.15
X3 VPWR A Y VPB sky130_fd_pr__pfet_01v8_hvt ad=0.26 pd=2.52 as=0.135 ps=1.27 w=1 l=0.15
.ends

.subckt sky130_fd_sc_hd__a221oi_2 B2 C1 A2 A1 B1 Y VGND VPWR VPB VNB
X0 Y B1 a_383_47# VNB sky130_fd_pr__nfet_01v8 ad=0.08775 pd=0.92 as=0.08775 ps=0.92 w=0.65 l=0.15
X1 a_301_297# B1 a_27_297# VPB sky130_fd_pr__pfet_01v8_hvt ad=0.135 pd=1.27 as=0.135 ps=1.27 w=1 l=0.15
X2 a_301_297# A2 VPWR VPB sky130_fd_pr__pfet_01v8_hvt ad=0.285 pd=2.57 as=0.135 ps=1.27 w=1 l=0.15
X3 VGND B2 a_383_47# VNB sky130_fd_pr__nfet_01v8 ad=0.11375 pd=1 as=0.08775 ps=0.92 w=0.65 l=0.15
X4 Y A1 a_735_47# VNB sky130_fd_pr__nfet_01v8 ad=0.08775 pd=0.92 as=0.08775 ps=0.92 w=0.65 l=0.15
X5 a_27_297# B2 a_301_297# VPB sky130_fd_pr__pfet_01v8_hvt ad=0.135 pd=1.27 as=0.26 ps=2.52 w=1 l=0.15
X6 VPWR A1 a_301_297# VPB sky130_fd_pr__pfet_01v8_hvt ad=0.135 pd=1.27 as=0.135 ps=1.27 w=1 l=0.15
X7 VGND A2 a_735_47# VNB sky130_fd_pr__nfet_01v8 ad=0.169 pd=1.82 as=0.08775 ps=0.92 w=0.65 l=0.15
X8 a_301_297# A1 VPWR VPB sky130_fd_pr__pfet_01v8_hvt ad=0.135 pd=1.27 as=0.135 ps=1.27 w=1 l=0.15
X9 Y C1 a_27_297# VPB sky130_fd_pr__pfet_01v8_hvt ad=0.135 pd=1.27 as=0.27 ps=2.54 w=1 l=0.15
X10 VGND C1 Y VNB sky130_fd_pr__nfet_01v8 ad=0.25675 pd=1.44 as=0.08775 ps=0.92 w=0.65 l=0.15
X11 Y C1 VGND VNB sky130_fd_pr__nfet_01v8 ad=0.08775 pd=0.92 as=0.1755 ps=1.84 w=0.65 l=0.15
X12 VPWR A2 a_301_297# VPB sky130_fd_pr__pfet_01v8_hvt ad=0.135 pd=1.27 as=0.175 ps=1.35 w=1 l=0.15
X13 a_383_47# B2 VGND VNB sky130_fd_pr__nfet_01v8 ad=0.08775 pd=0.92 as=0.25675 ps=1.44 w=0.65 l=0.15
X14 a_383_47# B1 Y VNB sky130_fd_pr__nfet_01v8 ad=0.08775 pd=0.92 as=0.08775 ps=0.92 w=0.65 l=0.15
X15 a_735_47# A2 VGND VNB sky130_fd_pr__nfet_01v8 ad=0.08775 pd=0.92 as=0.11375 ps=1 w=0.65 l=0.15
X16 a_27_297# C1 Y VPB sky130_fd_pr__pfet_01v8_hvt ad=0.26 pd=2.52 as=0.135 ps=1.27 w=1 l=0.15
X17 a_301_297# B2 a_27_297# VPB sky130_fd_pr__pfet_01v8_hvt ad=0.175 pd=1.35 as=0.135 ps=1.27 w=1 l=0.15
X18 a_735_47# A1 Y VNB sky130_fd_pr__nfet_01v8 ad=0.08775 pd=0.92 as=0.08775 ps=0.92 w=0.65 l=0.15
X19 a_27_297# B1 a_301_297# VPB sky130_fd_pr__pfet_01v8_hvt ad=0.135 pd=1.27 as=0.135 ps=1.27 w=1 l=0.15
.ends

.subckt sky130_fd_sc_hd__nand2_2 Y A B VGND VPWR VPB VNB
X0 VPWR A Y VPB sky130_fd_pr__pfet_01v8_hvt ad=0.26 pd=2.52 as=0.135 ps=1.27 w=1 l=0.15
X1 Y A VPWR VPB sky130_fd_pr__pfet_01v8_hvt ad=0.135 pd=1.27 as=0.135 ps=1.27 w=1 l=0.15
X2 VPWR B Y VPB sky130_fd_pr__pfet_01v8_hvt ad=0.135 pd=1.27 as=0.135 ps=1.27 w=1 l=0.15
X3 a_27_47# B VGND VNB sky130_fd_pr__nfet_01v8 ad=0.08775 pd=0.92 as=0.08775 ps=0.92 w=0.65 l=0.15
X4 a_27_47# A Y VNB sky130_fd_pr__nfet_01v8 ad=0.169 pd=1.82 as=0.08775 ps=0.92 w=0.65 l=0.15
X5 Y A a_27_47# VNB sky130_fd_pr__nfet_01v8 ad=0.08775 pd=0.92 as=0.08775 ps=0.92 w=0.65 l=0.15
X6 Y B VPWR VPB sky130_fd_pr__pfet_01v8_hvt ad=0.135 pd=1.27 as=0.26 ps=2.52 w=1 l=0.15
X7 VGND B a_27_47# VNB sky130_fd_pr__nfet_01v8 ad=0.08775 pd=0.92 as=0.169 ps=1.82 w=0.65 l=0.15
.ends

.subckt sky130_fd_sc_hd__a21bo_2 B1_N A2 X A1 VGND VPWR VPB VNB
X0 VPWR A1 a_485_297# VPB sky130_fd_pr__pfet_01v8_hvt ad=0.135 pd=1.27 as=0.135 ps=1.27 w=1 l=0.15
X1 a_485_297# a_297_93# a_79_21# VPB sky130_fd_pr__pfet_01v8_hvt ad=0.135 pd=1.27 as=0.26 ps=2.52 w=1 l=0.15
X2 a_297_93# B1_N VGND VNB sky130_fd_pr__nfet_01v8 ad=0.1092 pd=1.36 as=0.108375 ps=1.01 w=0.42 l=0.15
X3 a_581_47# A1 a_79_21# VNB sky130_fd_pr__nfet_01v8 ad=0.06825 pd=0.86 as=0.10725 ps=0.98 w=0.65 l=0.15
X4 VGND a_79_21# X VNB sky130_fd_pr__nfet_01v8 ad=0.108375 pd=1.01 as=0.091 ps=0.93 w=0.65 l=0.15
X5 a_79_21# a_297_93# VGND VNB sky130_fd_pr__nfet_01v8 ad=0.10725 pd=0.98 as=0.169 ps=1.82 w=0.65 l=0.15
X6 VGND A2 a_581_47# VNB sky130_fd_pr__nfet_01v8 ad=0.169 pd=1.82 as=0.06825 ps=0.86 w=0.65 l=0.15
X7 VPWR a_79_21# X VPB sky130_fd_pr__pfet_01v8_hvt ad=0.1815 pd=1.51 as=0.14 ps=1.28 w=1 l=0.15
X8 a_297_93# B1_N VPWR VPB sky130_fd_pr__pfet_01v8_hvt ad=0.1092 pd=1.36 as=0.1815 ps=1.51 w=0.42 l=0.15
X9 X a_79_21# VPWR VPB sky130_fd_pr__pfet_01v8_hvt ad=0.14 pd=1.28 as=0.26 ps=2.52 w=1 l=0.15
X10 a_485_297# A2 VPWR VPB sky130_fd_pr__pfet_01v8_hvt ad=0.26 pd=2.52 as=0.135 ps=1.27 w=1 l=0.15
X11 X a_79_21# VGND VNB sky130_fd_pr__nfet_01v8 ad=0.091 pd=0.93 as=0.169 ps=1.82 w=0.65 l=0.15
.ends

.subckt sky130_fd_sc_hd__a31oi_2 A3 B1 Y A1 A2 VPWR VGND VPB VNB
X0 VGND B1 Y VNB sky130_fd_pr__nfet_01v8 ad=0.11375 pd=1 as=0.117 ps=1.01 w=0.65 l=0.15
X1 VPWR A1 a_27_297# VPB sky130_fd_pr__pfet_01v8_hvt ad=0.41 pd=1.82 as=0.135 ps=1.27 w=1 l=0.15
X2 a_27_297# A2 VPWR VPB sky130_fd_pr__pfet_01v8_hvt ad=0.135 pd=1.27 as=0.135 ps=1.27 w=1 l=0.15
X3 a_27_297# B1 Y VPB sky130_fd_pr__pfet_01v8_hvt ad=0.26 pd=2.52 as=0.175 ps=1.35 w=1 l=0.15
X4 a_277_47# A1 Y VNB sky130_fd_pr__nfet_01v8 ad=0.0975 pd=0.95 as=0.169 ps=1.82 w=0.65 l=0.15
X5 VPWR A2 a_27_297# VPB sky130_fd_pr__pfet_01v8_hvt ad=0.135 pd=1.27 as=0.135 ps=1.27 w=1 l=0.15
X6 a_27_297# A3 VPWR VPB sky130_fd_pr__pfet_01v8_hvt ad=0.135 pd=1.27 as=0.135 ps=1.27 w=1 l=0.15
X7 a_27_47# A3 VGND VNB sky130_fd_pr__nfet_01v8 ad=0.08775 pd=0.92 as=0.08775 ps=0.92 w=0.65 l=0.15
X8 a_27_47# A2 a_277_47# VNB sky130_fd_pr__nfet_01v8 ad=0.169 pd=1.82 as=0.08775 ps=0.92 w=0.65 l=0.15
X9 a_27_297# A1 VPWR VPB sky130_fd_pr__pfet_01v8_hvt ad=0.18 pd=1.36 as=0.41 ps=1.82 w=1 l=0.15
X10 Y B1 a_27_297# VPB sky130_fd_pr__pfet_01v8_hvt ad=0.175 pd=1.35 as=0.18 ps=1.36 w=1 l=0.15
X11 a_277_47# A2 a_27_47# VNB sky130_fd_pr__nfet_01v8 ad=0.08775 pd=0.92 as=0.08775 ps=0.92 w=0.65 l=0.15
X12 Y B1 VGND VNB sky130_fd_pr__nfet_01v8 ad=0.169 pd=1.82 as=0.11375 ps=1 w=0.65 l=0.15
X13 Y A1 a_277_47# VNB sky130_fd_pr__nfet_01v8 ad=0.117 pd=1.01 as=0.0975 ps=0.95 w=0.65 l=0.15
X14 VPWR A3 a_27_297# VPB sky130_fd_pr__pfet_01v8_hvt ad=0.135 pd=1.27 as=0.26 ps=2.52 w=1 l=0.15
X15 VGND A3 a_27_47# VNB sky130_fd_pr__nfet_01v8 ad=0.08775 pd=0.92 as=0.169 ps=1.82 w=0.65 l=0.15
.ends

.subckt sky130_fd_sc_hd__o311a_2 X A2 A3 A1 B1 C1 VPWR VGND VPB VNB
X0 X a_91_21# VPWR VPB sky130_fd_pr__pfet_01v8_hvt ad=0.135 pd=1.27 as=0.32 ps=2.64 w=1 l=0.15
X1 a_91_21# C1 VPWR VPB sky130_fd_pr__pfet_01v8_hvt ad=0.26 pd=2.52 as=0.15 ps=1.3 w=1 l=0.15
X2 a_360_47# A3 VGND VNB sky130_fd_pr__nfet_01v8 ad=0.118625 pd=1.015 as=0.1365 ps=1.07 w=0.65 l=0.15
X3 VPWR B1 a_91_21# VPB sky130_fd_pr__pfet_01v8_hvt ad=0.15 pd=1.3 as=0.1375 ps=1.275 w=1 l=0.15
X4 a_360_297# A1 VPWR VPB sky130_fd_pr__pfet_01v8_hvt ad=0.175 pd=1.35 as=0.3125 ps=1.625 w=1 l=0.15
X5 VGND A2 a_360_47# VNB sky130_fd_pr__nfet_01v8 ad=0.1365 pd=1.07 as=0.11375 ps=1 w=0.65 l=0.15
X6 a_360_47# A1 VGND VNB sky130_fd_pr__nfet_01v8 ad=0.11375 pd=1 as=0.203125 ps=1.275 w=0.65 l=0.15
X7 VPWR a_91_21# X VPB sky130_fd_pr__pfet_01v8_hvt ad=0.3125 pd=1.625 as=0.135 ps=1.27 w=1 l=0.15
X8 VGND a_91_21# X VNB sky130_fd_pr__nfet_01v8 ad=0.203125 pd=1.275 as=0.08775 ps=0.92 w=0.65 l=0.15
X9 X a_91_21# VGND VNB sky130_fd_pr__nfet_01v8 ad=0.08775 pd=0.92 as=0.208 ps=1.94 w=0.65 l=0.15
X10 a_677_47# B1 a_360_47# VNB sky130_fd_pr__nfet_01v8 ad=0.06825 pd=0.86 as=0.118625 ps=1.015 w=0.65 l=0.15
X11 a_460_297# A2 a_360_297# VPB sky130_fd_pr__pfet_01v8_hvt ad=0.21 pd=1.42 as=0.175 ps=1.35 w=1 l=0.15
X12 a_91_21# C1 a_677_47# VNB sky130_fd_pr__nfet_01v8 ad=0.169 pd=1.82 as=0.06825 ps=0.86 w=0.65 l=0.15
X13 a_91_21# A3 a_460_297# VPB sky130_fd_pr__pfet_01v8_hvt ad=0.1375 pd=1.275 as=0.21 ps=1.42 w=1 l=0.15
.ends

.subckt sky130_fd_sc_hd__o32a_2 B1 B2 A3 A2 A1 X VGND VPWR VPB VNB
X0 a_429_297# A2 a_345_297# VPB sky130_fd_pr__pfet_01v8_hvt ad=0.215 pd=1.43 as=0.135 ps=1.27 w=1 l=0.15
X1 VGND A2 a_345_47# VNB sky130_fd_pr__nfet_01v8 ad=0.13975 pd=1.08 as=0.08775 ps=0.92 w=0.65 l=0.15
X2 VPWR a_79_21# X VPB sky130_fd_pr__pfet_01v8_hvt ad=0.305 pd=1.61 as=0.135 ps=1.27 w=1 l=0.15
X3 VGND a_79_21# X VNB sky130_fd_pr__nfet_01v8 ad=0.19825 pd=1.26 as=0.08775 ps=0.92 w=0.65 l=0.15
X4 a_345_47# A3 VGND VNB sky130_fd_pr__nfet_01v8 ad=0.08775 pd=0.92 as=0.13975 ps=1.08 w=0.65 l=0.15
X5 a_345_297# A1 VPWR VPB sky130_fd_pr__pfet_01v8_hvt ad=0.135 pd=1.27 as=0.305 ps=1.61 w=1 l=0.15
X6 a_629_297# B2 a_79_21# VPB sky130_fd_pr__pfet_01v8_hvt ad=0.19 pd=1.38 as=0.135 ps=1.27 w=1 l=0.15
X7 VPWR B1 a_629_297# VPB sky130_fd_pr__pfet_01v8_hvt ad=0.33 pd=2.66 as=0.19 ps=1.38 w=1 l=0.15
X8 a_79_21# B2 a_345_47# VNB sky130_fd_pr__nfet_01v8 ad=0.1235 pd=1.03 as=0.08775 ps=0.92 w=0.65 l=0.15
X9 a_345_47# B1 a_79_21# VNB sky130_fd_pr__nfet_01v8 ad=0.2145 pd=1.96 as=0.1235 ps=1.03 w=0.65 l=0.15
X10 a_79_21# A3 a_429_297# VPB sky130_fd_pr__pfet_01v8_hvt ad=0.135 pd=1.27 as=0.215 ps=1.43 w=1 l=0.15
X11 X a_79_21# VPWR VPB sky130_fd_pr__pfet_01v8_hvt ad=0.135 pd=1.27 as=0.26 ps=2.52 w=1 l=0.15
X12 X a_79_21# VGND VNB sky130_fd_pr__nfet_01v8 ad=0.08775 pd=0.92 as=0.169 ps=1.82 w=0.65 l=0.15
X13 a_345_47# A1 VGND VNB sky130_fd_pr__nfet_01v8 ad=0.08775 pd=0.92 as=0.19825 ps=1.26 w=0.65 l=0.15
.ends

.subckt sky130_fd_sc_hd__a21boi_2 B1_N A2 A1 Y VPWR VGND VPB VNB
X0 Y a_61_47# VGND VNB sky130_fd_pr__nfet_01v8 ad=0.08775 pd=0.92 as=0.183125 ps=1.24 w=0.65 l=0.15
X1 VPWR A2 a_217_297# VPB sky130_fd_pr__pfet_01v8_hvt ad=0.135 pd=1.27 as=0.135 ps=1.27 w=1 l=0.15
X2 a_217_297# a_61_47# Y VPB sky130_fd_pr__pfet_01v8_hvt ad=0.135 pd=1.27 as=0.135 ps=1.27 w=1 l=0.15
X3 a_479_47# A2 VGND VNB sky130_fd_pr__nfet_01v8 ad=0.06825 pd=0.86 as=0.10725 ps=0.98 w=0.65 l=0.15
X4 a_217_297# A2 VPWR VPB sky130_fd_pr__pfet_01v8_hvt ad=0.285 pd=2.57 as=0.14 ps=1.28 w=1 l=0.15
X5 Y a_61_47# a_217_297# VPB sky130_fd_pr__pfet_01v8_hvt ad=0.135 pd=1.27 as=0.26 ps=2.52 w=1 l=0.15
X6 VPWR A1 a_217_297# VPB sky130_fd_pr__pfet_01v8_hvt ad=0.14 pd=1.28 as=0.14 ps=1.28 w=1 l=0.15
X7 a_61_47# B1_N VPWR VPB sky130_fd_pr__pfet_01v8_hvt ad=0.1113 pd=1.37 as=0.1113 ps=1.37 w=0.42 l=0.15
X8 VGND A2 a_637_47# VNB sky130_fd_pr__nfet_01v8 ad=0.18525 pd=1.87 as=0.091 ps=0.93 w=0.65 l=0.15
X9 VGND a_61_47# Y VNB sky130_fd_pr__nfet_01v8 ad=0.10725 pd=0.98 as=0.08775 ps=0.92 w=0.65 l=0.15
X10 Y A1 a_479_47# VNB sky130_fd_pr__nfet_01v8 ad=0.091 pd=0.93 as=0.06825 ps=0.86 w=0.65 l=0.15
X11 VGND B1_N a_61_47# VNB sky130_fd_pr__nfet_01v8 ad=0.183125 pd=1.24 as=0.126 ps=1.44 w=0.42 l=0.15
X12 a_217_297# A1 VPWR VPB sky130_fd_pr__pfet_01v8_hvt ad=0.14 pd=1.28 as=0.135 ps=1.27 w=1 l=0.15
X13 a_637_47# A1 Y VNB sky130_fd_pr__nfet_01v8 ad=0.091 pd=0.93 as=0.091 ps=0.93 w=0.65 l=0.15
.ends

.subckt sky130_fd_sc_hd__o22a_2 A2 X B1 A1 B2 VGND VPWR VPB VNB
X0 a_301_47# B2 a_81_21# VNB sky130_fd_pr__nfet_01v8 ad=0.1235 pd=1.03 as=0.08775 ps=0.92 w=0.65 l=0.15
X1 VGND A2 a_301_47# VNB sky130_fd_pr__nfet_01v8 ad=0.08775 pd=0.92 as=0.1235 ps=1.03 w=0.65 l=0.15
X2 a_383_297# B1 VPWR VPB sky130_fd_pr__pfet_01v8_hvt ad=0.105 pd=1.21 as=0.39 ps=1.78 w=1 l=0.15
X3 VPWR a_81_21# X VPB sky130_fd_pr__pfet_01v8_hvt ad=0.39 pd=1.78 as=0.135 ps=1.27 w=1 l=0.15
X4 a_301_47# A1 VGND VNB sky130_fd_pr__nfet_01v8 ad=0.169 pd=1.82 as=0.08775 ps=0.92 w=0.65 l=0.15
X5 VGND a_81_21# X VNB sky130_fd_pr__nfet_01v8 ad=0.169 pd=1.82 as=0.08775 ps=0.92 w=0.65 l=0.15
X6 X a_81_21# VGND VNB sky130_fd_pr__nfet_01v8 ad=0.08775 pd=0.92 as=0.169 ps=1.82 w=0.65 l=0.15
X7 X a_81_21# VPWR VPB sky130_fd_pr__pfet_01v8_hvt ad=0.135 pd=1.27 as=0.28 ps=2.56 w=1 l=0.15
X8 VPWR A1 a_579_297# VPB sky130_fd_pr__pfet_01v8_hvt ad=0.28 pd=2.56 as=0.105 ps=1.21 w=1 l=0.15
X9 a_81_21# B1 a_301_47# VNB sky130_fd_pr__nfet_01v8 ad=0.08775 pd=0.92 as=0.169 ps=1.82 w=0.65 l=0.15
X10 a_579_297# A2 a_81_21# VPB sky130_fd_pr__pfet_01v8_hvt ad=0.105 pd=1.21 as=0.235 ps=1.47 w=1 l=0.15
X11 a_81_21# B2 a_383_297# VPB sky130_fd_pr__pfet_01v8_hvt ad=0.235 pd=1.47 as=0.105 ps=1.21 w=1 l=0.15
.ends

.subckt sky130_fd_sc_hd__and4b_2 X A_N D C B VPWR VGND VPB VNB
X0 VPWR a_193_413# X VPB sky130_fd_pr__pfet_01v8_hvt ad=0.26 pd=2.52 as=0.1525 ps=1.305 w=1 l=0.15
X1 a_297_47# a_27_413# a_193_413# VNB sky130_fd_pr__nfet_01v8 ad=0.0441 pd=0.63 as=0.1092 ps=1.36 w=0.42 l=0.15
X2 a_369_47# B a_297_47# VNB sky130_fd_pr__nfet_01v8 ad=0.0735 pd=0.77 as=0.0441 ps=0.63 w=0.42 l=0.15
X3 X a_193_413# VGND VNB sky130_fd_pr__nfet_01v8 ad=0.099125 pd=0.955 as=0.103975 ps=1 w=0.65 l=0.15
X4 VPWR D a_193_413# VPB sky130_fd_pr__pfet_01v8_hvt ad=0.14325 pd=1.33 as=0.06615 ps=0.735 w=0.42 l=0.15
X5 VPWR A_N a_27_413# VPB sky130_fd_pr__pfet_01v8_hvt ad=0.0567 pd=0.69 as=0.1092 ps=1.36 w=0.42 l=0.15
X6 VGND D a_469_47# VNB sky130_fd_pr__nfet_01v8 ad=0.103975 pd=1 as=0.06195 ps=0.715 w=0.42 l=0.15
X7 VGND a_193_413# X VNB sky130_fd_pr__nfet_01v8 ad=0.169 pd=1.82 as=0.099125 ps=0.955 w=0.65 l=0.15
X8 VPWR B a_193_413# VPB sky130_fd_pr__pfet_01v8_hvt ad=0.1281 pd=1.03 as=0.0987 ps=0.89 w=0.42 l=0.15
X9 a_193_413# C VPWR VPB sky130_fd_pr__pfet_01v8_hvt ad=0.06615 pd=0.735 as=0.1281 ps=1.03 w=0.42 l=0.15
X10 X a_193_413# VPWR VPB sky130_fd_pr__pfet_01v8_hvt ad=0.1525 pd=1.305 as=0.14325 ps=1.33 w=1 l=0.15
X11 a_193_413# a_27_413# VPWR VPB sky130_fd_pr__pfet_01v8_hvt ad=0.0987 pd=0.89 as=0.0567 ps=0.69 w=0.42 l=0.15
X12 a_469_47# C a_369_47# VNB sky130_fd_pr__nfet_01v8 ad=0.06195 pd=0.715 as=0.0735 ps=0.77 w=0.42 l=0.15
X13 a_27_413# A_N VGND VNB sky130_fd_pr__nfet_01v8 ad=0.1092 pd=1.36 as=0.1092 ps=1.36 w=0.42 l=0.15
.ends

.subckt sky130_fd_sc_hd__nor3_2 C Y A B VGND VPWR VPB VNB
X0 Y C a_281_297# VPB sky130_fd_pr__pfet_01v8_hvt ad=0.135 pd=1.27 as=0.26 ps=2.52 w=1 l=0.15
X1 a_281_297# B a_27_297# VPB sky130_fd_pr__pfet_01v8_hvt ad=0.135 pd=1.27 as=0.135 ps=1.27 w=1 l=0.15
X2 Y B VGND VNB sky130_fd_pr__nfet_01v8 ad=0.08775 pd=0.92 as=0.08775 ps=0.92 w=0.65 l=0.15
X3 a_27_297# A VPWR VPB sky130_fd_pr__pfet_01v8_hvt ad=0.135 pd=1.27 as=0.135 ps=1.27 w=1 l=0.15
X4 VGND A Y VNB sky130_fd_pr__nfet_01v8 ad=0.08775 pd=0.92 as=0.08775 ps=0.92 w=0.65 l=0.15
X5 Y A VGND VNB sky130_fd_pr__nfet_01v8 ad=0.08775 pd=0.92 as=0.17875 ps=1.85 w=0.65 l=0.15
X6 VGND B Y VNB sky130_fd_pr__nfet_01v8 ad=0.169 pd=1.82 as=0.08775 ps=0.92 w=0.65 l=0.15
X7 VGND C Y VNB sky130_fd_pr__nfet_01v8 ad=0.169 pd=1.82 as=0.08775 ps=0.92 w=0.65 l=0.15
X8 Y C VGND VNB sky130_fd_pr__nfet_01v8 ad=0.08775 pd=0.92 as=0.169 ps=1.82 w=0.65 l=0.15
X9 VPWR A a_27_297# VPB sky130_fd_pr__pfet_01v8_hvt ad=0.135 pd=1.27 as=0.28 ps=2.56 w=1 l=0.15
X10 a_281_297# C Y VPB sky130_fd_pr__pfet_01v8_hvt ad=0.26 pd=2.52 as=0.135 ps=1.27 w=1 l=0.15
X11 a_27_297# B a_281_297# VPB sky130_fd_pr__pfet_01v8_hvt ad=0.28 pd=2.56 as=0.135 ps=1.27 w=1 l=0.15
.ends

.subckt sky130_fd_sc_hd__a221o_2 X B1 A1 B2 A2 VGND VPWR C1 VPB VNB
X0 VPWR a_27_47# X VPB sky130_fd_pr__pfet_01v8_hvt ad=0.285 pd=2.57 as=0.135 ps=1.27 w=1 l=0.15
X1 a_465_47# A1 a_27_47# VNB sky130_fd_pr__nfet_01v8 ad=0.10725 pd=0.98 as=0.169 ps=1.82 w=0.65 l=0.15
X2 X a_27_47# VPWR VPB sky130_fd_pr__pfet_01v8_hvt ad=0.135 pd=1.27 as=0.1575 ps=1.315 w=1 l=0.15
X3 a_109_297# B1 a_193_297# VPB sky130_fd_pr__pfet_01v8_hvt ad=0.26 pd=2.52 as=0.135 ps=1.27 w=1 l=0.15
X4 a_193_297# B2 a_109_297# VPB sky130_fd_pr__pfet_01v8_hvt ad=0.135 pd=1.27 as=0.135 ps=1.27 w=1 l=0.15
X5 X a_27_47# VGND VNB sky130_fd_pr__nfet_01v8 ad=0.08775 pd=0.92 as=0.102375 ps=0.965 w=0.65 l=0.15
X6 a_205_47# B2 VGND VNB sky130_fd_pr__nfet_01v8 ad=0.06825 pd=0.86 as=0.10725 ps=0.98 w=0.65 l=0.15
X7 VPWR A2 a_193_297# VPB sky130_fd_pr__pfet_01v8_hvt ad=0.1575 pd=1.315 as=0.165 ps=1.33 w=1 l=0.15
X8 a_193_297# A1 VPWR VPB sky130_fd_pr__pfet_01v8_hvt ad=0.165 pd=1.33 as=0.26 ps=2.52 w=1 l=0.15
X9 a_27_47# B1 a_205_47# VNB sky130_fd_pr__nfet_01v8 ad=0.169 pd=1.82 as=0.06825 ps=0.86 w=0.65 l=0.15
X10 VGND a_27_47# X VNB sky130_fd_pr__nfet_01v8 ad=0.18525 pd=1.87 as=0.08775 ps=0.92 w=0.65 l=0.15
X11 a_109_297# C1 a_27_47# VPB sky130_fd_pr__pfet_01v8_hvt ad=0.135 pd=1.27 as=0.26 ps=2.52 w=1 l=0.15
X12 VGND C1 a_27_47# VNB sky130_fd_pr__nfet_01v8 ad=0.10725 pd=0.98 as=0.169 ps=1.82 w=0.65 l=0.15
X13 VGND A2 a_465_47# VNB sky130_fd_pr__nfet_01v8 ad=0.102375 pd=0.965 as=0.10725 ps=0.98 w=0.65 l=0.15
.ends

.subckt sky130_fd_sc_hd__o21a_2 A1 B1 A2 X VGND VPWR VPB VNB
X0 VPWR A1 a_470_297# VPB sky130_fd_pr__pfet_01v8_hvt ad=0.265 pd=2.53 as=0.16 ps=1.32 w=1 l=0.15
X1 a_79_21# B1 VPWR VPB sky130_fd_pr__pfet_01v8_hvt ad=0.14 pd=1.28 as=0.4 ps=1.8 w=1 l=0.15
X2 VGND a_79_21# X VNB sky130_fd_pr__nfet_01v8 ad=0.17225 pd=1.83 as=0.089375 ps=0.925 w=0.65 l=0.15
X3 VGND A2 a_384_47# VNB sky130_fd_pr__nfet_01v8 ad=0.104 pd=0.97 as=0.091 ps=0.93 w=0.65 l=0.15
X4 a_470_297# A2 a_79_21# VPB sky130_fd_pr__pfet_01v8_hvt ad=0.16 pd=1.32 as=0.14 ps=1.28 w=1 l=0.15
X5 VPWR a_79_21# X VPB sky130_fd_pr__pfet_01v8_hvt ad=0.4 pd=1.8 as=0.1375 ps=1.275 w=1 l=0.15
X6 a_384_47# B1 a_79_21# VNB sky130_fd_pr__nfet_01v8 ad=0.091 pd=0.93 as=0.17225 ps=1.83 w=0.65 l=0.15
X7 a_384_47# A1 VGND VNB sky130_fd_pr__nfet_01v8 ad=0.17225 pd=1.83 as=0.104 ps=0.97 w=0.65 l=0.15
X8 X a_79_21# VPWR VPB sky130_fd_pr__pfet_01v8_hvt ad=0.1375 pd=1.275 as=0.26 ps=2.52 w=1 l=0.15
X9 X a_79_21# VGND VNB sky130_fd_pr__nfet_01v8 ad=0.089375 pd=0.925 as=0.169 ps=1.82 w=0.65 l=0.15
.ends

.subckt sky130_fd_sc_hd__and2_2 A X B VPWR VGND VPB VNB
X0 X a_61_75# VPWR VPB sky130_fd_pr__pfet_01v8_hvt ad=0.195 pd=1.39 as=0.16655 ps=1.39 w=1 l=0.15
X1 VPWR a_61_75# X VPB sky130_fd_pr__pfet_01v8_hvt ad=0.38 pd=2.76 as=0.195 ps=1.39 w=1 l=0.15
X2 VPWR B a_61_75# VPB sky130_fd_pr__pfet_01v8_hvt ad=0.16655 pd=1.39 as=0.0567 ps=0.69 w=0.42 l=0.15
X3 VGND B a_147_75# VNB sky130_fd_pr__nfet_01v8 ad=0.1118 pd=1.04 as=0.0567 ps=0.69 w=0.42 l=0.15
X4 X a_61_75# VGND VNB sky130_fd_pr__nfet_01v8 ad=0.12675 pd=1.04 as=0.1118 ps=1.04 w=0.65 l=0.15
X5 VGND a_61_75# X VNB sky130_fd_pr__nfet_01v8 ad=0.247 pd=2.06 as=0.12675 ps=1.04 w=0.65 l=0.15
X6 a_61_75# A VPWR VPB sky130_fd_pr__pfet_01v8_hvt ad=0.0567 pd=0.69 as=0.1176 ps=1.4 w=0.42 l=0.15
X7 a_147_75# A a_61_75# VNB sky130_fd_pr__nfet_01v8 ad=0.0567 pd=0.69 as=0.1176 ps=1.4 w=0.42 l=0.15
.ends

.subckt sky130_fd_sc_hd__a211o_2 X A2 A1 B1 C1 VGND VPWR VPB VNB
X0 a_79_21# A1 a_348_47# VNB sky130_fd_pr__nfet_01v8 ad=0.115375 pd=1.005 as=0.13325 ps=1.06 w=0.65 l=0.15
X1 a_79_21# C1 VGND VNB sky130_fd_pr__nfet_01v8 ad=0.169 pd=1.82 as=0.10725 ps=0.98 w=0.65 l=0.15
X2 VGND a_79_21# X VNB sky130_fd_pr__nfet_01v8 ad=0.199875 pd=1.265 as=0.091 ps=0.93 w=0.65 l=0.15
X3 VPWR a_79_21# X VPB sky130_fd_pr__pfet_01v8_hvt ad=0.26 pd=2.52 as=0.135 ps=1.27 w=1 l=0.15
X4 a_79_21# C1 a_585_297# VPB sky130_fd_pr__pfet_01v8_hvt ad=0.26 pd=2.52 as=0.105 ps=1.21 w=1 l=0.15
X5 VPWR A2 a_299_297# VPB sky130_fd_pr__pfet_01v8_hvt ad=0.195 pd=1.39 as=0.26 ps=2.52 w=1 l=0.15
X6 a_299_297# A1 VPWR VPB sky130_fd_pr__pfet_01v8_hvt ad=0.165 pd=1.33 as=0.195 ps=1.39 w=1 l=0.15
X7 a_585_297# B1 a_299_297# VPB sky130_fd_pr__pfet_01v8_hvt ad=0.105 pd=1.21 as=0.165 ps=1.33 w=1 l=0.15
X8 a_348_47# A2 VGND VNB sky130_fd_pr__nfet_01v8 ad=0.13325 pd=1.06 as=0.199875 ps=1.265 w=0.65 l=0.15
X9 X a_79_21# VPWR VPB sky130_fd_pr__pfet_01v8_hvt ad=0.135 pd=1.27 as=0.26 ps=2.52 w=1 l=0.15
X10 X a_79_21# VGND VNB sky130_fd_pr__nfet_01v8 ad=0.091 pd=0.93 as=0.169 ps=1.82 w=0.65 l=0.15
X11 VGND B1 a_79_21# VNB sky130_fd_pr__nfet_01v8 ad=0.10725 pd=0.98 as=0.115375 ps=1.005 w=0.65 l=0.15
.ends

.subckt sky130_fd_sc_hd__dfxtp_2 Q CLK D VPWR VGND VPB VNB
X0 Q a_1059_315# VGND VNB sky130_fd_pr__nfet_01v8 ad=0.08775 pd=0.92 as=0.08775 ps=0.92 w=0.65 l=0.15
X1 VPWR a_1059_315# Q VPB sky130_fd_pr__pfet_01v8_hvt ad=0.26 pd=2.52 as=0.135 ps=1.27 w=1 l=0.15
X2 a_891_413# a_193_47# a_634_159# VNB sky130_fd_pr__special_nfet_01v8 ad=0.0684 pd=0.74 as=0.0989 ps=0.995 w=0.36 l=0.15
X3 a_561_413# a_27_47# a_466_413# VPB sky130_fd_pr__pfet_01v8_hvt ad=0.07665 pd=0.785 as=0.06825 ps=0.745 w=0.42 l=0.15
X4 VPWR CLK a_27_47# VPB sky130_fd_pr__pfet_01v8_hvt ad=0.0864 pd=0.91 as=0.1664 ps=1.8 w=0.64 l=0.15
X5 Q a_1059_315# VPWR VPB sky130_fd_pr__pfet_01v8_hvt ad=0.135 pd=1.27 as=0.135 ps=1.27 w=1 l=0.15
X6 a_381_47# D VPWR VPB sky130_fd_pr__pfet_01v8_hvt ad=0.05775 pd=0.695 as=0.1092 ps=1.36 w=0.42 l=0.15
X7 VGND a_634_159# a_592_47# VNB sky130_fd_pr__nfet_01v8 ad=0.12095 pd=1.085 as=0.0696 ps=0.765 w=0.42 l=0.15
X8 VGND a_1059_315# Q VNB sky130_fd_pr__nfet_01v8 ad=0.169 pd=1.82 as=0.08775 ps=0.92 w=0.65 l=0.15
X9 VPWR a_891_413# a_1059_315# VPB sky130_fd_pr__pfet_01v8_hvt ad=0.135 pd=1.27 as=0.27 ps=2.54 w=1 l=0.15
X10 a_466_413# a_193_47# a_381_47# VPB sky130_fd_pr__pfet_01v8_hvt ad=0.06825 pd=0.745 as=0.05775 ps=0.695 w=0.42 l=0.15
X11 VPWR a_634_159# a_561_413# VPB sky130_fd_pr__pfet_01v8_hvt ad=0.178875 pd=1.26 as=0.07665 ps=0.785 w=0.42 l=0.15
X12 a_634_159# a_466_413# VGND VNB sky130_fd_pr__nfet_01v8 ad=0.0989 pd=0.995 as=0.12095 ps=1.085 w=0.64 l=0.15
X13 a_634_159# a_466_413# VPWR VPB sky130_fd_pr__pfet_01v8_hvt ad=0.1095 pd=1.075 as=0.178875 ps=1.26 w=0.75 l=0.15
X14 a_975_413# a_193_47# a_891_413# VPB sky130_fd_pr__pfet_01v8_hvt ad=0.0882 pd=0.84 as=0.0567 ps=0.69 w=0.42 l=0.15
X15 VGND a_1059_315# a_1017_47# VNB sky130_fd_pr__nfet_01v8 ad=0.1092 pd=1.36 as=0.066 ps=0.745 w=0.42 l=0.15
X16 a_193_47# a_27_47# VGND VNB sky130_fd_pr__nfet_01v8 ad=0.1092 pd=1.36 as=0.0567 ps=0.69 w=0.42 l=0.15
X17 a_891_413# a_27_47# a_634_159# VPB sky130_fd_pr__pfet_01v8_hvt ad=0.0567 pd=0.69 as=0.1095 ps=1.075 w=0.42 l=0.15
X18 a_592_47# a_193_47# a_466_413# VNB sky130_fd_pr__special_nfet_01v8 ad=0.0696 pd=0.765 as=0.0621 ps=0.705 w=0.36 l=0.15
X19 VPWR a_1059_315# a_975_413# VPB sky130_fd_pr__pfet_01v8_hvt ad=0.1113 pd=1.37 as=0.0882 ps=0.84 w=0.42 l=0.15
X20 a_1017_47# a_27_47# a_891_413# VNB sky130_fd_pr__special_nfet_01v8 ad=0.066 pd=0.745 as=0.0684 ps=0.74 w=0.36 l=0.15
X21 a_193_47# a_27_47# VPWR VPB sky130_fd_pr__pfet_01v8_hvt ad=0.1664 pd=1.8 as=0.0864 ps=0.91 w=0.64 l=0.15
X22 a_466_413# a_27_47# a_381_47# VNB sky130_fd_pr__special_nfet_01v8 ad=0.0621 pd=0.705 as=0.0813 ps=0.83 w=0.36 l=0.15
X23 VGND a_891_413# a_1059_315# VNB sky130_fd_pr__nfet_01v8 ad=0.08775 pd=0.92 as=0.169 ps=1.82 w=0.65 l=0.15
X24 a_381_47# D VGND VNB sky130_fd_pr__nfet_01v8 ad=0.0813 pd=0.83 as=0.1092 ps=1.36 w=0.42 l=0.15
X25 VGND CLK a_27_47# VNB sky130_fd_pr__nfet_01v8 ad=0.0567 pd=0.69 as=0.1092 ps=1.36 w=0.42 l=0.15
.ends

.subckt sky130_fd_sc_hd__buf_2 VPWR VGND X A VPB VNB
X0 VPWR a_27_47# X VPB sky130_fd_pr__pfet_01v8_hvt ad=0.265 pd=2.53 as=0.135 ps=1.27 w=1 l=0.15
X1 X a_27_47# VPWR VPB sky130_fd_pr__pfet_01v8_hvt ad=0.135 pd=1.27 as=0.149 ps=1.325 w=1 l=0.15
X2 VPWR A a_27_47# VPB sky130_fd_pr__pfet_01v8_hvt ad=0.149 pd=1.325 as=0.1664 ps=1.8 w=0.64 l=0.15
X3 X a_27_47# VGND VNB sky130_fd_pr__nfet_01v8 ad=0.08775 pd=0.92 as=0.097 ps=0.975 w=0.65 l=0.15
X4 VGND a_27_47# X VNB sky130_fd_pr__nfet_01v8 ad=0.17225 pd=1.83 as=0.08775 ps=0.92 w=0.65 l=0.15
X5 VGND A a_27_47# VNB sky130_fd_pr__nfet_01v8 ad=0.097 pd=0.975 as=0.1092 ps=1.36 w=0.42 l=0.15
.ends

.subckt sky130_fd_sc_hd__or3b_2 A B C_N X VPWR VGND VPB VNB
X0 a_388_297# A VPWR VPB sky130_fd_pr__pfet_01v8_hvt ad=0.0567 pd=0.69 as=0.14825 ps=1.34 w=0.42 l=0.15
X1 VPWR C_N a_27_47# VPB sky130_fd_pr__pfet_01v8_hvt ad=0.14575 pd=1.335 as=0.1092 ps=1.36 w=0.42 l=0.15
X2 VGND a_176_21# X VNB sky130_fd_pr__nfet_01v8 ad=0.101875 pd=0.99 as=0.08775 ps=0.92 w=0.65 l=0.15
X3 X a_176_21# VGND VNB sky130_fd_pr__nfet_01v8 ad=0.08775 pd=0.92 as=0.10025 ps=0.985 w=0.65 l=0.15
X4 VPWR a_176_21# X VPB sky130_fd_pr__pfet_01v8_hvt ad=0.14825 pd=1.34 as=0.135 ps=1.27 w=1 l=0.15
X5 VGND B a_176_21# VNB sky130_fd_pr__nfet_01v8 ad=0.0567 pd=0.69 as=0.0567 ps=0.69 w=0.42 l=0.15
X6 X a_176_21# VPWR VPB sky130_fd_pr__pfet_01v8_hvt ad=0.135 pd=1.27 as=0.14575 ps=1.335 w=1 l=0.15
X7 a_176_21# a_27_47# a_472_297# VPB sky130_fd_pr__pfet_01v8_hvt ad=0.1092 pd=1.36 as=0.0567 ps=0.69 w=0.42 l=0.15
X8 a_472_297# B a_388_297# VPB sky130_fd_pr__pfet_01v8_hvt ad=0.0567 pd=0.69 as=0.0567 ps=0.69 w=0.42 l=0.15
X9 a_176_21# A VGND VNB sky130_fd_pr__nfet_01v8 ad=0.0567 pd=0.69 as=0.101875 ps=0.99 w=0.42 l=0.15
X10 a_176_21# a_27_47# VGND VNB sky130_fd_pr__nfet_01v8 ad=0.1092 pd=1.36 as=0.0567 ps=0.69 w=0.42 l=0.15
X11 VGND C_N a_27_47# VNB sky130_fd_pr__nfet_01v8 ad=0.10025 pd=0.985 as=0.1092 ps=1.36 w=0.42 l=0.15
.ends

.subckt sky130_fd_sc_hd__o21bai_2 B1_N Y A2 A1 VGND VPWR VPB VNB
X0 a_397_297# A2 Y VPB sky130_fd_pr__pfet_01v8_hvt ad=0.135 pd=1.27 as=0.135 ps=1.27 w=1 l=0.15
X1 VPWR B1_N a_28_297# VPB sky130_fd_pr__pfet_01v8_hvt ad=0.14575 pd=1.335 as=0.1092 ps=1.36 w=0.42 l=0.15
X2 Y A2 a_397_297# VPB sky130_fd_pr__pfet_01v8_hvt ad=0.135 pd=1.27 as=0.26 ps=2.52 w=1 l=0.15
X3 VGND A2 a_229_47# VNB sky130_fd_pr__nfet_01v8 ad=0.08775 pd=0.92 as=0.08775 ps=0.92 w=0.65 l=0.15
X4 VGND A1 a_229_47# VNB sky130_fd_pr__nfet_01v8 ad=0.08775 pd=0.92 as=0.08775 ps=0.92 w=0.65 l=0.15
X5 a_28_297# B1_N VGND VNB sky130_fd_pr__nfet_01v8 ad=0.1092 pd=1.36 as=0.1092 ps=1.36 w=0.42 l=0.15
X6 Y a_28_297# a_229_47# VNB sky130_fd_pr__nfet_01v8 ad=0.08775 pd=0.92 as=0.169 ps=1.82 w=0.65 l=0.15
X7 VPWR a_28_297# Y VPB sky130_fd_pr__pfet_01v8_hvt ad=0.26 pd=2.52 as=0.135 ps=1.27 w=1 l=0.15
X8 a_397_297# A1 VPWR VPB sky130_fd_pr__pfet_01v8_hvt ad=0.28 pd=2.56 as=0.135 ps=1.27 w=1 l=0.15
X9 a_229_47# a_28_297# Y VNB sky130_fd_pr__nfet_01v8 ad=0.08775 pd=0.92 as=0.08775 ps=0.92 w=0.65 l=0.15
X10 Y a_28_297# VPWR VPB sky130_fd_pr__pfet_01v8_hvt ad=0.135 pd=1.27 as=0.14575 ps=1.335 w=1 l=0.15
X11 a_229_47# A2 VGND VNB sky130_fd_pr__nfet_01v8 ad=0.08775 pd=0.92 as=0.08775 ps=0.92 w=0.65 l=0.15
X12 a_229_47# A1 VGND VNB sky130_fd_pr__nfet_01v8 ad=0.182 pd=1.86 as=0.08775 ps=0.92 w=0.65 l=0.15
X13 VPWR A1 a_397_297# VPB sky130_fd_pr__pfet_01v8_hvt ad=0.135 pd=1.27 as=0.135 ps=1.27 w=1 l=0.15
.ends

.subckt sky130_fd_sc_hd__a41oi_2 A4 A3 A2 B1 A1 Y VPWR VGND VPB VNB
X0 a_149_297# B1 Y VPB sky130_fd_pr__pfet_01v8_hvt ad=0.135 pd=1.27 as=0.135 ps=1.27 w=1 l=0.15
X1 a_757_47# A4 VGND VNB sky130_fd_pr__nfet_01v8 ad=0.169 pd=1.82 as=0.08775 ps=0.92 w=0.65 l=0.15
X2 a_757_47# A3 a_567_47# VNB sky130_fd_pr__nfet_01v8 ad=0.08775 pd=0.92 as=0.08775 ps=0.92 w=0.65 l=0.15
X3 VPWR A3 a_149_297# VPB sky130_fd_pr__pfet_01v8_hvt ad=0.385 pd=1.77 as=0.145 ps=1.29 w=1 l=0.15
X4 Y B1 a_149_297# VPB sky130_fd_pr__pfet_01v8_hvt ad=0.135 pd=1.27 as=0.26 ps=2.52 w=1 l=0.15
X5 Y B1 VGND VNB sky130_fd_pr__nfet_01v8 ad=0.08775 pd=0.92 as=0.169 ps=1.82 w=0.65 l=0.15
X6 a_567_47# A3 a_757_47# VNB sky130_fd_pr__nfet_01v8 ad=0.08775 pd=0.92 as=0.169 ps=1.82 w=0.65 l=0.15
X7 VGND A4 a_757_47# VNB sky130_fd_pr__nfet_01v8 ad=0.08775 pd=0.92 as=0.08775 ps=0.92 w=0.65 l=0.15
X8 VPWR A4 a_149_297# VPB sky130_fd_pr__pfet_01v8_hvt ad=0.135 pd=1.27 as=0.135 ps=1.27 w=1 l=0.15
X9 a_149_297# A4 VPWR VPB sky130_fd_pr__pfet_01v8_hvt ad=0.26 pd=2.52 as=0.135 ps=1.27 w=1 l=0.15
X10 a_317_47# A1 Y VNB sky130_fd_pr__nfet_01v8 ad=0.08775 pd=0.92 as=0.08775 ps=0.92 w=0.65 l=0.15
X11 a_317_47# A2 a_567_47# VNB sky130_fd_pr__nfet_01v8 ad=0.169 pd=1.82 as=0.08775 ps=0.92 w=0.65 l=0.15
X12 a_149_297# A3 VPWR VPB sky130_fd_pr__pfet_01v8_hvt ad=0.135 pd=1.27 as=0.385 ps=1.77 w=1 l=0.15
X13 a_149_297# A2 VPWR VPB sky130_fd_pr__pfet_01v8_hvt ad=0.145 pd=1.29 as=0.135 ps=1.27 w=1 l=0.15
X14 Y A1 a_317_47# VNB sky130_fd_pr__nfet_01v8 ad=0.08775 pd=0.92 as=0.169 ps=1.82 w=0.65 l=0.15
X15 VPWR A2 a_149_297# VPB sky130_fd_pr__pfet_01v8_hvt ad=0.135 pd=1.27 as=0.135 ps=1.27 w=1 l=0.15
X16 a_567_47# A2 a_317_47# VNB sky130_fd_pr__nfet_01v8 ad=0.08775 pd=0.92 as=0.08775 ps=0.92 w=0.65 l=0.15
X17 a_149_297# A1 VPWR VPB sky130_fd_pr__pfet_01v8_hvt ad=0.135 pd=1.27 as=0.135 ps=1.27 w=1 l=0.15
X18 VGND B1 Y VNB sky130_fd_pr__nfet_01v8 ad=0.169 pd=1.82 as=0.08775 ps=0.92 w=0.65 l=0.15
X19 VPWR A1 a_149_297# VPB sky130_fd_pr__pfet_01v8_hvt ad=0.135 pd=1.27 as=0.135 ps=1.27 w=1 l=0.15
.ends

.subckt sky130_fd_sc_hd__a32o_2 B2 X A2 A3 A1 B1 VGND VPWR VPB VNB
X0 VPWR A3 a_299_297# VPB sky130_fd_pr__pfet_01v8_hvt ad=0.26 pd=2.52 as=0.135 ps=1.27 w=1 l=0.15
X1 a_299_297# A2 VPWR VPB sky130_fd_pr__pfet_01v8_hvt ad=0.135 pd=1.27 as=0.215 ps=1.43 w=1 l=0.15
X2 a_352_47# B2 VGND VNB sky130_fd_pr__nfet_01v8 ad=0.115375 pd=1.005 as=0.209625 ps=1.295 w=0.65 l=0.15
X3 a_549_47# A1 a_21_199# VNB sky130_fd_pr__nfet_01v8 ad=0.13975 pd=1.08 as=0.10725 ps=0.98 w=0.65 l=0.15
X4 X a_21_199# VPWR VPB sky130_fd_pr__pfet_01v8_hvt ad=0.26 pd=2.52 as=0.135 ps=1.27 w=1 l=0.15
X5 VGND a_21_199# X VNB sky130_fd_pr__nfet_01v8 ad=0.209625 pd=1.295 as=0.08775 ps=0.92 w=0.65 l=0.15
X6 a_665_47# A2 a_549_47# VNB sky130_fd_pr__nfet_01v8 ad=0.08775 pd=0.92 as=0.13975 ps=1.08 w=0.65 l=0.15
X7 VPWR A1 a_299_297# VPB sky130_fd_pr__pfet_01v8_hvt ad=0.215 pd=1.43 as=0.135 ps=1.27 w=1 l=0.15
X8 a_299_297# B1 a_21_199# VPB sky130_fd_pr__pfet_01v8_hvt ad=0.135 pd=1.27 as=0.135 ps=1.27 w=1 l=0.15
X9 a_21_199# B2 a_299_297# VPB sky130_fd_pr__pfet_01v8_hvt ad=0.135 pd=1.27 as=0.26 ps=2.52 w=1 l=0.15
X10 VGND A3 a_665_47# VNB sky130_fd_pr__nfet_01v8 ad=0.169 pd=1.82 as=0.08775 ps=0.92 w=0.65 l=0.15
X11 VPWR a_21_199# X VPB sky130_fd_pr__pfet_01v8_hvt ad=0.135 pd=1.27 as=0.26 ps=2.52 w=1 l=0.15
X12 X a_21_199# VGND VNB sky130_fd_pr__nfet_01v8 ad=0.08775 pd=0.92 as=0.169 ps=1.82 w=0.65 l=0.15
X13 a_21_199# B1 a_352_47# VNB sky130_fd_pr__nfet_01v8 ad=0.10725 pd=0.98 as=0.115375 ps=1.005 w=0.65 l=0.15
.ends

.subckt sky130_fd_sc_hd__a22o_2 A1 A2 X B2 B1 VPWR VGND VPB VNB
X0 VPWR a_27_297# X VPB sky130_fd_pr__pfet_01v8_hvt ad=0.27 pd=2.54 as=0.135 ps=1.27 w=1 l=0.15
X1 VGND A2 a_381_47# VNB sky130_fd_pr__nfet_01v8 ad=0.102375 pd=0.965 as=0.10725 ps=0.98 w=0.65 l=0.15
X2 X a_27_297# VGND VNB sky130_fd_pr__nfet_01v8 ad=0.08775 pd=0.92 as=0.102375 ps=0.965 w=0.65 l=0.15
X3 X a_27_297# VPWR VPB sky130_fd_pr__pfet_01v8_hvt ad=0.135 pd=1.27 as=0.1575 ps=1.315 w=1 l=0.15
X4 a_27_297# B1 a_109_47# VNB sky130_fd_pr__nfet_01v8 ad=0.169 pd=1.82 as=0.07475 ps=0.88 w=0.65 l=0.15
X5 a_27_297# B1 a_109_297# VPB sky130_fd_pr__pfet_01v8_hvt ad=0.26 pd=2.52 as=0.135 ps=1.27 w=1 l=0.15
X6 VGND a_27_297# X VNB sky130_fd_pr__nfet_01v8 ad=0.1755 pd=1.84 as=0.08775 ps=0.92 w=0.65 l=0.15
X7 a_109_297# A1 VPWR VPB sky130_fd_pr__pfet_01v8_hvt ad=0.165 pd=1.33 as=0.26 ps=2.52 w=1 l=0.15
X8 VPWR A2 a_109_297# VPB sky130_fd_pr__pfet_01v8_hvt ad=0.1575 pd=1.315 as=0.165 ps=1.33 w=1 l=0.15
X9 a_381_47# A1 a_27_297# VNB sky130_fd_pr__nfet_01v8 ad=0.10725 pd=0.98 as=0.169 ps=1.82 w=0.65 l=0.15
X10 a_109_297# B2 a_27_297# VPB sky130_fd_pr__pfet_01v8_hvt ad=0.135 pd=1.27 as=0.26 ps=2.52 w=1 l=0.15
X11 a_109_47# B2 VGND VNB sky130_fd_pr__nfet_01v8 ad=0.07475 pd=0.88 as=0.169 ps=1.82 w=0.65 l=0.15
.ends

.subckt sky130_fd_sc_hd__diode_2 DIODE VGND VPWR VPB VNB
X0 VNB DIODE sky130_fd_pr__diode_pw2nd_05v5 perim=2.64e+06 area=4.347e+11
.ends

.subckt sky130_fd_sc_hd__a311o_2 X C1 B1 A1 A2 A3 VGND VPWR VPB VNB
X0 a_79_21# C1 a_635_297# VPB sky130_fd_pr__pfet_01v8_hvt ad=0.26 pd=2.52 as=0.21 ps=1.42 w=1 l=0.15
X1 VPWR A2 a_319_297# VPB sky130_fd_pr__pfet_01v8_hvt ad=0.185 pd=1.37 as=0.17 ps=1.34 w=1 l=0.15
X2 VGND B1 a_79_21# VNB sky130_fd_pr__nfet_01v8 ad=0.13975 pd=1.08 as=0.13325 ps=1.06 w=0.65 l=0.15
X3 a_417_47# A2 a_319_47# VNB sky130_fd_pr__nfet_01v8 ad=0.12025 pd=1.02 as=0.1105 ps=0.99 w=0.65 l=0.15
X4 a_79_21# A1 a_417_47# VNB sky130_fd_pr__nfet_01v8 ad=0.13325 pd=1.06 as=0.12025 ps=1.02 w=0.65 l=0.15
X5 a_319_47# A3 VGND VNB sky130_fd_pr__nfet_01v8 ad=0.1105 pd=0.99 as=0.156 ps=1.13 w=0.65 l=0.15
X6 VPWR a_79_21# X VPB sky130_fd_pr__pfet_01v8_hvt ad=0.24 pd=1.48 as=0.135 ps=1.27 w=1 l=0.15
X7 a_319_297# A1 VPWR VPB sky130_fd_pr__pfet_01v8_hvt ad=0.21 pd=1.42 as=0.185 ps=1.37 w=1 l=0.15
X8 VGND a_79_21# X VNB sky130_fd_pr__nfet_01v8 ad=0.156 pd=1.13 as=0.08775 ps=0.92 w=0.65 l=0.15
X9 a_319_297# A3 VPWR VPB sky130_fd_pr__pfet_01v8_hvt ad=0.17 pd=1.34 as=0.24 ps=1.48 w=1 l=0.15
X10 a_79_21# C1 VGND VNB sky130_fd_pr__nfet_01v8 ad=0.169 pd=1.82 as=0.13975 ps=1.08 w=0.65 l=0.15
X11 a_635_297# B1 a_319_297# VPB sky130_fd_pr__pfet_01v8_hvt ad=0.21 pd=1.42 as=0.21 ps=1.42 w=1 l=0.15
X12 X a_79_21# VPWR VPB sky130_fd_pr__pfet_01v8_hvt ad=0.135 pd=1.27 as=0.26 ps=2.52 w=1 l=0.15
X13 X a_79_21# VGND VNB sky130_fd_pr__nfet_01v8 ad=0.08775 pd=0.92 as=0.169 ps=1.82 w=0.65 l=0.15
.ends

.subckt sky130_fd_sc_hd__dfstp_2 Q D VPWR SET_B CLK VGND VPB VNB
X0 VGND a_652_21# a_586_47# VNB sky130_fd_pr__nfet_01v8 ad=0.0882 pd=0.84 as=0.06705 ps=0.75 w=0.42 l=0.15
X1 a_956_413# a_476_47# VPWR VPB sky130_fd_pr__pfet_01v8_hvt ad=0.0441 pd=0.63 as=0.0567 ps=0.69 w=0.42 l=0.15
X2 a_1136_413# a_193_47# a_1028_413# VPB sky130_fd_pr__pfet_01v8_hvt ad=0.0441 pd=0.63 as=0.0819 ps=0.81 w=0.42 l=0.15
X3 VPWR a_476_47# a_652_21# VPB sky130_fd_pr__pfet_01v8_hvt ad=0.0567 pd=0.69 as=0.0567 ps=0.69 w=0.42 l=0.15
X4 a_1228_47# a_27_47# a_1028_413# VNB sky130_fd_pr__nfet_01v8 ad=0.0441 pd=0.63 as=0.0735 ps=0.77 w=0.42 l=0.15
X5 VPWR CLK a_27_47# VPB sky130_fd_pr__pfet_01v8_hvt ad=0.0864 pd=0.91 as=0.1664 ps=1.8 w=0.64 l=0.15
X6 a_586_47# a_193_47# a_476_47# VNB sky130_fd_pr__special_nfet_01v8 ad=0.06705 pd=0.75 as=0.072 ps=0.76 w=0.36 l=0.15
X7 a_1056_47# a_476_47# VGND VNB sky130_fd_pr__nfet_01v8 ad=0.0441 pd=0.63 as=0.1092 ps=1.36 w=0.42 l=0.15
X8 a_476_47# a_27_47# a_381_47# VNB sky130_fd_pr__special_nfet_01v8 ad=0.072 pd=0.76 as=0.0935 ps=0.965 w=0.36 l=0.15
X9 a_381_47# D VPWR VPB sky130_fd_pr__pfet_01v8_hvt ad=0.12495 pd=1.175 as=0.2184 ps=2.2 w=0.84 l=0.15
X10 a_652_21# SET_B VPWR VPB sky130_fd_pr__pfet_01v8_hvt ad=0.0567 pd=0.69 as=0.0798 ps=0.8 w=0.42 l=0.15
X11 VPWR a_1602_47# Q VPB sky130_fd_pr__pfet_01v8_hvt ad=0.26 pd=2.52 as=0.135 ps=1.27 w=1 l=0.15
X12 a_562_413# a_27_47# a_476_47# VPB sky130_fd_pr__pfet_01v8_hvt ad=0.0945 pd=0.87 as=0.0567 ps=0.69 w=0.42 l=0.15
X13 VGND a_1028_413# a_1602_47# VNB sky130_fd_pr__nfet_01v8 ad=0.08775 pd=0.92 as=0.169 ps=1.82 w=0.65 l=0.15
X14 VGND a_1602_47# Q VNB sky130_fd_pr__nfet_01v8 ad=0.169 pd=1.82 as=0.08775 ps=0.92 w=0.65 l=0.15
X15 Q a_1602_47# VPWR VPB sky130_fd_pr__pfet_01v8_hvt ad=0.135 pd=1.27 as=0.135 ps=1.27 w=1 l=0.15
X16 a_1028_413# a_193_47# a_1056_47# VNB sky130_fd_pr__nfet_01v8 ad=0.0735 pd=0.77 as=0.0441 ps=0.63 w=0.42 l=0.15
X17 a_476_47# a_193_47# a_381_47# VPB sky130_fd_pr__pfet_01v8_hvt ad=0.0567 pd=0.69 as=0.12495 ps=1.175 w=0.42 l=0.15
X18 a_193_47# a_27_47# VGND VNB sky130_fd_pr__nfet_01v8 ad=0.1092 pd=1.36 as=0.0567 ps=0.69 w=0.42 l=0.15
X19 VPWR a_1028_413# a_1602_47# VPB sky130_fd_pr__pfet_01v8_hvt ad=0.135 pd=1.27 as=0.26 ps=2.52 w=1 l=0.15
X20 VPWR a_652_21# a_562_413# VPB sky130_fd_pr__pfet_01v8_hvt ad=0.0798 pd=0.8 as=0.0945 ps=0.87 w=0.42 l=0.15
X21 Q a_1602_47# VGND VNB sky130_fd_pr__nfet_01v8 ad=0.08775 pd=0.92 as=0.08775 ps=0.92 w=0.65 l=0.15
X22 a_1028_413# a_27_47# a_956_413# VPB sky130_fd_pr__pfet_01v8_hvt ad=0.0819 pd=0.81 as=0.0441 ps=0.63 w=0.42 l=0.15
X23 VPWR a_1178_261# a_1136_413# VPB sky130_fd_pr__pfet_01v8_hvt ad=0.1092 pd=1.36 as=0.0441 ps=0.63 w=0.42 l=0.15
X24 a_193_47# a_27_47# VPWR VPB sky130_fd_pr__pfet_01v8_hvt ad=0.1664 pd=1.8 as=0.0864 ps=0.91 w=0.64 l=0.15
X25 a_1178_261# a_1028_413# VPWR VPB sky130_fd_pr__pfet_01v8_hvt ad=0.2226 pd=2.21 as=0.12075 ps=1.165 w=0.84 l=0.15
X26 a_796_47# SET_B VGND VNB sky130_fd_pr__nfet_01v8 ad=0.0441 pd=0.63 as=0.0882 ps=0.84 w=0.42 l=0.15
X27 a_1300_47# a_1178_261# a_1228_47# VNB sky130_fd_pr__nfet_01v8 ad=0.0441 pd=0.63 as=0.0441 ps=0.63 w=0.42 l=0.15
X28 a_381_47# D VGND VNB sky130_fd_pr__nfet_01v8 ad=0.0935 pd=0.965 as=0.1664 ps=1.8 w=0.64 l=0.15
X29 a_1178_261# a_1028_413# VGND VNB sky130_fd_pr__nfet_01v8 ad=0.1404 pd=1.6 as=0.1137 ps=1.01 w=0.54 l=0.15
X30 a_652_21# a_476_47# a_796_47# VNB sky130_fd_pr__nfet_01v8 ad=0.1092 pd=1.36 as=0.0441 ps=0.63 w=0.42 l=0.15
X31 VPWR SET_B a_1028_413# VPB sky130_fd_pr__pfet_01v8_hvt ad=0.12075 pd=1.165 as=0.1092 ps=1.36 w=0.42 l=0.15
X32 VGND CLK a_27_47# VNB sky130_fd_pr__nfet_01v8 ad=0.0567 pd=0.69 as=0.1092 ps=1.36 w=0.42 l=0.15
X33 VGND SET_B a_1300_47# VNB sky130_fd_pr__nfet_01v8 ad=0.1137 pd=1.01 as=0.0441 ps=0.63 w=0.42 l=0.15
.ends

.subckt sky130_fd_sc_hd__clkbuf_16 X A VGND VPWR VPB VNB
X0 VPWR A a_110_47# VPB sky130_fd_pr__pfet_01v8_hvt ad=0.14 pd=1.28 as=0.14 ps=1.28 w=1 l=0.15
X1 VPWR a_110_47# X VPB sky130_fd_pr__pfet_01v8_hvt ad=0.14 pd=1.28 as=0.14 ps=1.28 w=1 l=0.15
X2 X a_110_47# VPWR VPB sky130_fd_pr__pfet_01v8_hvt ad=0.14 pd=1.28 as=0.14 ps=1.28 w=1 l=0.15
X3 X a_110_47# VPWR VPB sky130_fd_pr__pfet_01v8_hvt ad=0.14 pd=1.28 as=0.14 ps=1.28 w=1 l=0.15
X4 VPWR a_110_47# X VPB sky130_fd_pr__pfet_01v8_hvt ad=0.14 pd=1.28 as=0.14 ps=1.28 w=1 l=0.15
X5 VPWR a_110_47# X VPB sky130_fd_pr__pfet_01v8_hvt ad=0.265 pd=2.53 as=0.14 ps=1.28 w=1 l=0.15
X6 a_110_47# A VPWR VPB sky130_fd_pr__pfet_01v8_hvt ad=0.14 pd=1.28 as=0.265 ps=2.53 w=1 l=0.15
X7 a_110_47# A VGND VNB sky130_fd_pr__nfet_01v8 ad=0.0588 pd=0.7 as=0.0588 ps=0.7 w=0.42 l=0.15
X8 VGND a_110_47# X VNB sky130_fd_pr__nfet_01v8 ad=0.0588 pd=0.7 as=0.0588 ps=0.7 w=0.42 l=0.15
X9 X a_110_47# VGND VNB sky130_fd_pr__nfet_01v8 ad=0.0588 pd=0.7 as=0.0588 ps=0.7 w=0.42 l=0.15
X10 VGND a_110_47# X VNB sky130_fd_pr__nfet_01v8 ad=0.0588 pd=0.7 as=0.0588 ps=0.7 w=0.42 l=0.15
X11 a_110_47# A VPWR VPB sky130_fd_pr__pfet_01v8_hvt ad=0.14 pd=1.28 as=0.14 ps=1.28 w=1 l=0.15
X12 VGND A a_110_47# VNB sky130_fd_pr__nfet_01v8 ad=0.0588 pd=0.7 as=0.0588 ps=0.7 w=0.42 l=0.15
X13 VGND a_110_47# X VNB sky130_fd_pr__nfet_01v8 ad=0.05775 pd=0.695 as=0.0588 ps=0.7 w=0.42 l=0.15
X14 VPWR a_110_47# X VPB sky130_fd_pr__pfet_01v8_hvt ad=0.14 pd=1.28 as=0.14 ps=1.28 w=1 l=0.15
X15 X a_110_47# VPWR VPB sky130_fd_pr__pfet_01v8_hvt ad=0.14 pd=1.28 as=0.14 ps=1.28 w=1 l=0.15
X16 VGND A a_110_47# VNB sky130_fd_pr__nfet_01v8 ad=0.0588 pd=0.7 as=0.0588 ps=0.7 w=0.42 l=0.15
X17 VGND a_110_47# X VNB sky130_fd_pr__nfet_01v8 ad=0.1113 pd=1.37 as=0.0588 ps=0.7 w=0.42 l=0.15
X18 VPWR a_110_47# X VPB sky130_fd_pr__pfet_01v8_hvt ad=0.1375 pd=1.275 as=0.14 ps=1.28 w=1 l=0.15
X19 VGND a_110_47# X VNB sky130_fd_pr__nfet_01v8 ad=0.0588 pd=0.7 as=0.0588 ps=0.7 w=0.42 l=0.15
X20 X a_110_47# VPWR VPB sky130_fd_pr__pfet_01v8_hvt ad=0.14 pd=1.28 as=0.1375 ps=1.275 w=1 l=0.15
X21 a_110_47# A VGND VNB sky130_fd_pr__nfet_01v8 ad=0.0588 pd=0.7 as=0.1113 ps=1.37 w=0.42 l=0.15
X22 VPWR A a_110_47# VPB sky130_fd_pr__pfet_01v8_hvt ad=0.14 pd=1.28 as=0.14 ps=1.28 w=1 l=0.15
X23 VPWR a_110_47# X VPB sky130_fd_pr__pfet_01v8_hvt ad=0.14 pd=1.28 as=0.14 ps=1.28 w=1 l=0.15
X24 VPWR a_110_47# X VPB sky130_fd_pr__pfet_01v8_hvt ad=0.14 pd=1.28 as=0.14 ps=1.28 w=1 l=0.15
X25 VGND a_110_47# X VNB sky130_fd_pr__nfet_01v8 ad=0.0588 pd=0.7 as=0.0588 ps=0.7 w=0.42 l=0.15
X26 X a_110_47# VPWR VPB sky130_fd_pr__pfet_01v8_hvt ad=0.14 pd=1.28 as=0.14 ps=1.28 w=1 l=0.15
X27 VGND a_110_47# X VNB sky130_fd_pr__nfet_01v8 ad=0.0588 pd=0.7 as=0.0588 ps=0.7 w=0.42 l=0.15
X28 VGND a_110_47# X VNB sky130_fd_pr__nfet_01v8 ad=0.0588 pd=0.7 as=0.0588 ps=0.7 w=0.42 l=0.15
X29 X a_110_47# VGND VNB sky130_fd_pr__nfet_01v8 ad=0.0588 pd=0.7 as=0.0588 ps=0.7 w=0.42 l=0.15
X30 X a_110_47# VPWR VPB sky130_fd_pr__pfet_01v8_hvt ad=0.14 pd=1.28 as=0.14 ps=1.28 w=1 l=0.15
X31 X a_110_47# VPWR VPB sky130_fd_pr__pfet_01v8_hvt ad=0.14 pd=1.28 as=0.14 ps=1.28 w=1 l=0.15
X32 X a_110_47# VGND VNB sky130_fd_pr__nfet_01v8 ad=0.0588 pd=0.7 as=0.0588 ps=0.7 w=0.42 l=0.15
X33 VPWR a_110_47# X VPB sky130_fd_pr__pfet_01v8_hvt ad=0.14 pd=1.28 as=0.14 ps=1.28 w=1 l=0.15
X34 X a_110_47# VPWR VPB sky130_fd_pr__pfet_01v8_hvt ad=0.14 pd=1.28 as=0.14 ps=1.28 w=1 l=0.15
X35 X a_110_47# VGND VNB sky130_fd_pr__nfet_01v8 ad=0.0588 pd=0.7 as=0.0588 ps=0.7 w=0.42 l=0.15
X36 X a_110_47# VGND VNB sky130_fd_pr__nfet_01v8 ad=0.0588 pd=0.7 as=0.0588 ps=0.7 w=0.42 l=0.15
X37 X a_110_47# VGND VNB sky130_fd_pr__nfet_01v8 ad=0.0588 pd=0.7 as=0.0588 ps=0.7 w=0.42 l=0.15
X38 X a_110_47# VGND VNB sky130_fd_pr__nfet_01v8 ad=0.0588 pd=0.7 as=0.0588 ps=0.7 w=0.42 l=0.15
X39 X a_110_47# VGND VNB sky130_fd_pr__nfet_01v8 ad=0.0588 pd=0.7 as=0.05775 ps=0.695 w=0.42 l=0.15
.ends

.subckt sky130_fd_sc_hd__o31a_2 X A1 A2 B1 A3 VGND VPWR VPB VNB
X0 a_108_21# B1 a_346_47# VNB sky130_fd_pr__nfet_01v8 ad=0.2015 pd=1.92 as=0.10725 ps=0.98 w=0.65 l=0.15
X1 a_346_47# A3 VGND VNB sky130_fd_pr__nfet_01v8 ad=0.10725 pd=0.98 as=0.10725 ps=0.98 w=0.65 l=0.15
X2 X a_108_21# VGND VNB sky130_fd_pr__nfet_01v8 ad=0.11375 pd=1 as=0.26325 ps=2.11 w=0.65 l=0.15
X3 a_108_21# A3 a_430_297# VPB sky130_fd_pr__pfet_01v8_hvt ad=0.2125 pd=1.425 as=0.165 ps=1.33 w=1 l=0.15
X4 a_430_297# A2 a_346_297# VPB sky130_fd_pr__pfet_01v8_hvt ad=0.165 pd=1.33 as=0.135 ps=1.27 w=1 l=0.15
X5 VPWR a_108_21# X VPB sky130_fd_pr__pfet_01v8_hvt ad=0.195 pd=1.39 as=0.175 ps=1.35 w=1 l=0.15
X6 a_346_297# A1 VPWR VPB sky130_fd_pr__pfet_01v8_hvt ad=0.135 pd=1.27 as=0.195 ps=1.39 w=1 l=0.15
X7 VGND A2 a_346_47# VNB sky130_fd_pr__nfet_01v8 ad=0.10725 pd=0.98 as=0.08775 ps=0.92 w=0.65 l=0.15
X8 X a_108_21# VPWR VPB sky130_fd_pr__pfet_01v8_hvt ad=0.175 pd=1.35 as=0.405 ps=2.81 w=1 l=0.15
X9 VPWR B1 a_108_21# VPB sky130_fd_pr__pfet_01v8_hvt ad=0.34 pd=2.68 as=0.2125 ps=1.425 w=1 l=0.15
X10 VGND a_108_21# X VNB sky130_fd_pr__nfet_01v8 ad=0.12675 pd=1.04 as=0.11375 ps=1 w=0.65 l=0.15
X11 a_346_47# A1 VGND VNB sky130_fd_pr__nfet_01v8 ad=0.08775 pd=0.92 as=0.12675 ps=1.04 w=0.65 l=0.15
.ends

.subckt sky130_fd_sc_hd__and3b_2 B X A_N C VGND VPWR VPB VNB
X0 a_109_53# A_N VPWR VPB sky130_fd_pr__pfet_01v8_hvt ad=0.1092 pd=1.36 as=0.1092 ps=1.36 w=0.42 l=0.15
X1 X a_215_311# VGND VNB sky130_fd_pr__nfet_01v8 ad=0.08775 pd=0.92 as=0.12715 ps=1.095 w=0.65 l=0.15
X2 a_109_53# A_N VGND VNB sky130_fd_pr__nfet_01v8 ad=0.1176 pd=1.4 as=0.1092 ps=1.36 w=0.42 l=0.15
X3 VGND C a_373_53# VNB sky130_fd_pr__nfet_01v8 ad=0.12715 pd=1.095 as=0.05355 ps=0.675 w=0.42 l=0.15
X4 VGND a_215_311# X VNB sky130_fd_pr__nfet_01v8 ad=0.169 pd=1.82 as=0.08775 ps=0.92 w=0.65 l=0.15
X5 VPWR C a_215_311# VPB sky130_fd_pr__pfet_01v8_hvt ad=0.14575 pd=1.335 as=0.074375 ps=0.815 w=0.42 l=0.15
X6 VPWR a_215_311# X VPB sky130_fd_pr__pfet_01v8_hvt ad=0.26 pd=2.52 as=0.135 ps=1.27 w=1 l=0.15
X7 X a_215_311# VPWR VPB sky130_fd_pr__pfet_01v8_hvt ad=0.135 pd=1.27 as=0.14575 ps=1.335 w=1 l=0.15
X8 a_301_53# a_109_53# a_215_311# VNB sky130_fd_pr__nfet_01v8 ad=0.0441 pd=0.63 as=0.1092 ps=1.36 w=0.42 l=0.15
X9 a_215_311# B VPWR VPB sky130_fd_pr__pfet_01v8_hvt ad=0.074375 pd=0.815 as=0.0567 ps=0.69 w=0.42 l=0.15
X10 a_373_53# B a_301_53# VNB sky130_fd_pr__nfet_01v8 ad=0.05355 pd=0.675 as=0.0441 ps=0.63 w=0.42 l=0.15
X11 VPWR a_109_53# a_215_311# VPB sky130_fd_pr__pfet_01v8_hvt ad=0.0567 pd=0.69 as=0.1092 ps=1.36 w=0.42 l=0.15
.ends

.subckt sky130_fd_sc_hd__nor2_2 B Y A VGND VPWR VPB VNB
X0 Y B a_27_297# VPB sky130_fd_pr__pfet_01v8_hvt ad=0.135 pd=1.27 as=0.135 ps=1.27 w=1 l=0.15
X1 Y B VGND VNB sky130_fd_pr__nfet_01v8 ad=0.08775 pd=0.92 as=0.08775 ps=0.92 w=0.65 l=0.15
X2 a_27_297# A VPWR VPB sky130_fd_pr__pfet_01v8_hvt ad=0.135 pd=1.27 as=0.135 ps=1.27 w=1 l=0.15
X3 VGND A Y VNB sky130_fd_pr__nfet_01v8 ad=0.08775 pd=0.92 as=0.08775 ps=0.92 w=0.65 l=0.15
X4 Y A VGND VNB sky130_fd_pr__nfet_01v8 ad=0.08775 pd=0.92 as=0.182 ps=1.86 w=0.65 l=0.15
X5 VGND B Y VNB sky130_fd_pr__nfet_01v8 ad=0.169 pd=1.82 as=0.08775 ps=0.92 w=0.65 l=0.15
X6 VPWR A a_27_297# VPB sky130_fd_pr__pfet_01v8_hvt ad=0.135 pd=1.27 as=0.28 ps=2.56 w=1 l=0.15
X7 a_27_297# B Y VPB sky130_fd_pr__pfet_01v8_hvt ad=0.26 pd=2.52 as=0.135 ps=1.27 w=1 l=0.15
.ends

.subckt sky130_fd_sc_hd__nor4b_2 D_N Y C A B VGND VPWR VPB VNB
X0 VPWR D_N a_694_21# VPB sky130_fd_pr__pfet_01v8_hvt ad=0.1092 pd=1.36 as=0.1092 ps=1.36 w=0.42 l=0.15
X1 a_27_297# B a_277_297# VPB sky130_fd_pr__pfet_01v8_hvt ad=0.26 pd=2.52 as=0.135 ps=1.27 w=1 l=0.15
X2 a_474_297# a_694_21# Y VPB sky130_fd_pr__pfet_01v8_hvt ad=0.26 pd=2.52 as=0.135 ps=1.27 w=1 l=0.15
X3 a_277_297# B a_27_297# VPB sky130_fd_pr__pfet_01v8_hvt ad=0.135 pd=1.27 as=0.135 ps=1.27 w=1 l=0.15
X4 Y a_694_21# a_474_297# VPB sky130_fd_pr__pfet_01v8_hvt ad=0.135 pd=1.27 as=0.135 ps=1.27 w=1 l=0.15
X5 VGND C Y VNB sky130_fd_pr__nfet_01v8 ad=0.08775 pd=0.92 as=0.08775 ps=0.92 w=0.65 l=0.15
X6 VGND D_N a_694_21# VNB sky130_fd_pr__nfet_01v8 ad=0.1092 pd=1.36 as=0.1092 ps=1.36 w=0.42 l=0.15
X7 a_27_297# A VPWR VPB sky130_fd_pr__pfet_01v8_hvt ad=0.135 pd=1.27 as=0.135 ps=1.27 w=1 l=0.15
X8 VGND A Y VNB sky130_fd_pr__nfet_01v8 ad=0.08775 pd=0.92 as=0.08775 ps=0.92 w=0.65 l=0.15
X9 VGND B Y VNB sky130_fd_pr__nfet_01v8 ad=0.169 pd=1.82 as=0.08775 ps=0.92 w=0.65 l=0.15
X10 Y C VGND VNB sky130_fd_pr__nfet_01v8 ad=0.08775 pd=0.92 as=0.169 ps=1.82 w=0.65 l=0.15
X11 a_474_297# C a_277_297# VPB sky130_fd_pr__pfet_01v8_hvt ad=0.135 pd=1.27 as=0.135 ps=1.27 w=1 l=0.15
X12 Y B VGND VNB sky130_fd_pr__nfet_01v8 ad=0.08775 pd=0.92 as=0.08775 ps=0.92 w=0.65 l=0.15
X13 Y a_694_21# VGND VNB sky130_fd_pr__nfet_01v8 ad=0.08775 pd=0.92 as=0.08775 ps=0.92 w=0.65 l=0.15
X14 a_277_297# C a_474_297# VPB sky130_fd_pr__pfet_01v8_hvt ad=0.135 pd=1.27 as=0.26 ps=2.52 w=1 l=0.15
X15 VGND a_694_21# Y VNB sky130_fd_pr__nfet_01v8 ad=0.169 pd=1.82 as=0.08775 ps=0.92 w=0.65 l=0.15
X16 VPWR A a_27_297# VPB sky130_fd_pr__pfet_01v8_hvt ad=0.135 pd=1.27 as=0.26 ps=2.52 w=1 l=0.15
X17 Y A VGND VNB sky130_fd_pr__nfet_01v8 ad=0.08775 pd=0.92 as=0.169 ps=1.82 w=0.65 l=0.15
.ends

.subckt sky130_fd_sc_hd__conb_1 LO HI VGND VPWR VPB VNB
X0 VPWR HI sky130_fd_pr__res_generic_po w=0.48 l=0.045
X1 LO VGND sky130_fd_pr__res_generic_po w=0.48 l=0.045
.ends

.subckt sky130_fd_sc_hd__o22ai_2 B2 B1 Y A1 A2 VGND VPWR VPB VNB
X0 Y B2 a_27_297# VPB sky130_fd_pr__pfet_01v8_hvt ad=0.135 pd=1.27 as=0.135 ps=1.27 w=1 l=0.15
X1 Y B2 a_27_47# VNB sky130_fd_pr__nfet_01v8 ad=0.08775 pd=0.92 as=0.08775 ps=0.92 w=0.65 l=0.15
X2 a_27_297# B1 VPWR VPB sky130_fd_pr__pfet_01v8_hvt ad=0.135 pd=1.27 as=0.135 ps=1.27 w=1 l=0.15
X3 a_475_297# A1 VPWR VPB sky130_fd_pr__pfet_01v8_hvt ad=0.28 pd=2.56 as=0.135 ps=1.27 w=1 l=0.15
X4 a_27_47# A2 VGND VNB sky130_fd_pr__nfet_01v8 ad=0.08775 pd=0.92 as=0.08775 ps=0.92 w=0.65 l=0.15
X5 VPWR A1 a_475_297# VPB sky130_fd_pr__pfet_01v8_hvt ad=0.135 pd=1.27 as=0.135 ps=1.27 w=1 l=0.15
X6 a_27_47# A1 VGND VNB sky130_fd_pr__nfet_01v8 ad=0.169 pd=1.82 as=0.08775 ps=0.92 w=0.65 l=0.15
X7 a_27_47# B1 Y VNB sky130_fd_pr__nfet_01v8 ad=0.08775 pd=0.92 as=0.08775 ps=0.92 w=0.65 l=0.15
X8 Y B1 a_27_47# VNB sky130_fd_pr__nfet_01v8 ad=0.08775 pd=0.92 as=0.182 ps=1.86 w=0.65 l=0.15
X9 a_27_47# B2 Y VNB sky130_fd_pr__nfet_01v8 ad=0.26975 pd=1.48 as=0.08775 ps=0.92 w=0.65 l=0.15
X10 VGND A1 a_27_47# VNB sky130_fd_pr__nfet_01v8 ad=0.08775 pd=0.92 as=0.08775 ps=0.92 w=0.65 l=0.15
X11 VPWR B1 a_27_297# VPB sky130_fd_pr__pfet_01v8_hvt ad=0.135 pd=1.27 as=0.28 ps=2.56 w=1 l=0.15
X12 a_475_297# A2 Y VPB sky130_fd_pr__pfet_01v8_hvt ad=0.135 pd=1.27 as=0.135 ps=1.27 w=1 l=0.15
X13 Y A2 a_475_297# VPB sky130_fd_pr__pfet_01v8_hvt ad=0.135 pd=1.27 as=0.28 ps=2.56 w=1 l=0.15
X14 a_27_297# B2 Y VPB sky130_fd_pr__pfet_01v8_hvt ad=0.28 pd=2.56 as=0.135 ps=1.27 w=1 l=0.15
X15 VGND A2 a_27_47# VNB sky130_fd_pr__nfet_01v8 ad=0.08775 pd=0.92 as=0.26975 ps=1.48 w=0.65 l=0.15
.ends

.subckt sky130_fd_sc_hd__o21ai_2 B1 Y A2 A1 VGND VPWR VPB VNB
X0 VGND A2 a_29_47# VNB sky130_fd_pr__nfet_01v8 ad=0.12675 pd=1.04 as=0.091 ps=0.93 w=0.65 l=0.15
X1 Y B1 a_29_47# VNB sky130_fd_pr__nfet_01v8 ad=0.091 pd=0.93 as=0.091 ps=0.93 w=0.65 l=0.15
X2 VPWR B1 Y VPB sky130_fd_pr__pfet_01v8_hvt ad=0.265 pd=2.53 as=0.14 ps=1.28 w=1 l=0.15
X3 VPWR A1 a_112_297# VPB sky130_fd_pr__pfet_01v8_hvt ad=0.16 pd=1.32 as=0.175 ps=1.35 w=1 l=0.15
X4 a_29_47# A2 VGND VNB sky130_fd_pr__nfet_01v8 ad=0.091 pd=0.93 as=0.091 ps=0.93 w=0.65 l=0.15
X5 Y A2 a_112_297# VPB sky130_fd_pr__pfet_01v8_hvt ad=0.14 pd=1.28 as=0.14 ps=1.28 w=1 l=0.15
X6 VGND A1 a_29_47# VNB sky130_fd_pr__nfet_01v8 ad=0.091 pd=0.93 as=0.17225 ps=1.83 w=0.65 l=0.15
X7 a_112_297# A1 VPWR VPB sky130_fd_pr__pfet_01v8_hvt ad=0.14 pd=1.28 as=0.265 ps=2.53 w=1 l=0.15
X8 a_112_297# A2 Y VPB sky130_fd_pr__pfet_01v8_hvt ad=0.175 pd=1.35 as=0.14 ps=1.28 w=1 l=0.15
X9 a_29_47# B1 Y VNB sky130_fd_pr__nfet_01v8 ad=0.17225 pd=1.83 as=0.091 ps=0.93 w=0.65 l=0.15
X10 Y B1 VPWR VPB sky130_fd_pr__pfet_01v8_hvt ad=0.14 pd=1.28 as=0.16 ps=1.32 w=1 l=0.15
X11 a_29_47# A1 VGND VNB sky130_fd_pr__nfet_01v8 ad=0.091 pd=0.93 as=0.12675 ps=1.04 w=0.65 l=0.15
.ends

.subckt sky130_fd_sc_hd__nand3b_2 Y C A_N B VGND VPWR VPB VNB
X0 a_408_47# B a_218_47# VNB sky130_fd_pr__nfet_01v8 ad=0.08775 pd=0.92 as=0.08775 ps=0.92 w=0.65 l=0.15
X1 a_408_47# a_27_47# Y VNB sky130_fd_pr__nfet_01v8 ad=0.169 pd=1.82 as=0.08775 ps=0.92 w=0.65 l=0.15
X2 Y a_27_47# a_408_47# VNB sky130_fd_pr__nfet_01v8 ad=0.08775 pd=0.92 as=0.08775 ps=0.92 w=0.65 l=0.15
X3 VPWR A_N a_27_47# VPB sky130_fd_pr__pfet_01v8_hvt ad=0.17575 pd=1.395 as=0.1092 ps=1.36 w=0.42 l=0.15
X4 VGND C a_218_47# VNB sky130_fd_pr__nfet_01v8 ad=0.169 pd=1.82 as=0.08775 ps=0.92 w=0.65 l=0.15
X5 VPWR B Y VPB sky130_fd_pr__pfet_01v8_hvt ad=0.26 pd=2.52 as=0.135 ps=1.27 w=1 l=0.15
X6 a_218_47# C VGND VNB sky130_fd_pr__nfet_01v8 ad=0.08775 pd=0.92 as=0.11975 ps=1.045 w=0.65 l=0.15
X7 Y B VPWR VPB sky130_fd_pr__pfet_01v8_hvt ad=0.135 pd=1.27 as=0.135 ps=1.27 w=1 l=0.15
X8 VPWR C Y VPB sky130_fd_pr__pfet_01v8_hvt ad=0.135 pd=1.27 as=0.135 ps=1.27 w=1 l=0.15
X9 VPWR a_27_47# Y VPB sky130_fd_pr__pfet_01v8_hvt ad=0.26 pd=2.52 as=0.135 ps=1.27 w=1 l=0.15
X10 a_218_47# B a_408_47# VNB sky130_fd_pr__nfet_01v8 ad=0.08775 pd=0.92 as=0.169 ps=1.82 w=0.65 l=0.15
X11 Y C VPWR VPB sky130_fd_pr__pfet_01v8_hvt ad=0.135 pd=1.27 as=0.17575 ps=1.395 w=1 l=0.15
X12 Y a_27_47# VPWR VPB sky130_fd_pr__pfet_01v8_hvt ad=0.135 pd=1.27 as=0.26 ps=2.52 w=1 l=0.15
X13 VGND A_N a_27_47# VNB sky130_fd_pr__nfet_01v8 ad=0.11975 pd=1.045 as=0.1092 ps=1.36 w=0.42 l=0.15
.ends

.subckt sky130_fd_sc_hd__a2111oi_2 D1 C1 A2 A1 Y B1 VGND VPWR VPB VNB
X0 a_467_297# B1 a_28_297# VPB sky130_fd_pr__pfet_01v8_hvt ad=0.14 pd=1.28 as=0.16 ps=1.32 w=1 l=0.15
X1 a_287_297# D1 Y VPB sky130_fd_pr__pfet_01v8_hvt ad=0.14 pd=1.28 as=0.14 ps=1.28 w=1 l=0.15
X2 VPWR A2 a_467_297# VPB sky130_fd_pr__pfet_01v8_hvt ad=0.16 pd=1.32 as=0.14 ps=1.28 w=1 l=0.15
X3 a_923_47# A2 VGND VNB sky130_fd_pr__nfet_01v8 ad=0.091 pd=0.93 as=0.112125 ps=0.995 w=0.65 l=0.15
X4 Y B1 VGND VNB sky130_fd_pr__nfet_01v8 ad=0.091 pd=0.93 as=0.12675 ps=1.04 w=0.65 l=0.15
X5 a_28_297# B1 a_467_297# VPB sky130_fd_pr__pfet_01v8_hvt ad=0.26 pd=2.52 as=0.14 ps=1.28 w=1 l=0.15
X6 VGND C1 Y VNB sky130_fd_pr__nfet_01v8 ad=0.091 pd=0.93 as=0.18525 ps=1.87 w=0.65 l=0.15
X7 a_28_297# C1 a_287_297# VPB sky130_fd_pr__pfet_01v8_hvt ad=0.16 pd=1.32 as=0.14 ps=1.28 w=1 l=0.15
X8 Y A1 a_923_47# VNB sky130_fd_pr__nfet_01v8 ad=0.17225 pd=1.83 as=0.091 ps=0.93 w=0.65 l=0.15
X9 VGND A2 a_684_47# VNB sky130_fd_pr__nfet_01v8 ad=0.112125 pd=0.995 as=0.17875 ps=1.2 w=0.65 l=0.15
X10 Y D1 VGND VNB sky130_fd_pr__nfet_01v8 ad=0.091 pd=0.93 as=0.091 ps=0.93 w=0.65 l=0.15
X11 VGND B1 Y VNB sky130_fd_pr__nfet_01v8 ad=0.12675 pd=1.04 as=0.105625 ps=0.975 w=0.65 l=0.15
X12 Y D1 a_115_297# VPB sky130_fd_pr__pfet_01v8_hvt ad=0.14 pd=1.28 as=0.14 ps=1.28 w=1 l=0.15
X13 a_467_297# A1 VPWR VPB sky130_fd_pr__pfet_01v8_hvt ad=0.335 pd=2.67 as=0.16 ps=1.32 w=1 l=0.15
X14 VGND D1 Y VNB sky130_fd_pr__nfet_01v8 ad=0.12675 pd=1.04 as=0.091 ps=0.93 w=0.65 l=0.15
X15 Y C1 VGND VNB sky130_fd_pr__nfet_01v8 ad=0.105625 pd=0.975 as=0.12675 ps=1.04 w=0.65 l=0.15
X16 VPWR A1 a_467_297# VPB sky130_fd_pr__pfet_01v8_hvt ad=0.14 pd=1.28 as=0.26 ps=2.52 w=1 l=0.15
X17 a_115_297# C1 a_28_297# VPB sky130_fd_pr__pfet_01v8_hvt ad=0.14 pd=1.28 as=0.285 ps=2.57 w=1 l=0.15
X18 a_467_297# A2 VPWR VPB sky130_fd_pr__pfet_01v8_hvt ad=0.14 pd=1.28 as=0.14 ps=1.28 w=1 l=0.15
X19 a_684_47# A1 Y VNB sky130_fd_pr__nfet_01v8 ad=0.17875 pd=1.2 as=0.091 ps=0.93 w=0.65 l=0.15
.ends

.subckt sky130_fd_sc_hd__nand3_2 A Y B C VGND VPWR VPB VNB
X0 VGND C a_277_47# VNB sky130_fd_pr__nfet_01v8 ad=0.2015 pd=1.92 as=0.08775 ps=0.92 w=0.65 l=0.15
X1 VPWR B Y VPB sky130_fd_pr__pfet_01v8_hvt ad=0.26 pd=2.52 as=0.135 ps=1.27 w=1 l=0.15
X2 a_277_47# C VGND VNB sky130_fd_pr__nfet_01v8 ad=0.08775 pd=0.92 as=0.169 ps=1.82 w=0.65 l=0.15
X3 Y B VPWR VPB sky130_fd_pr__pfet_01v8_hvt ad=0.135 pd=1.27 as=0.135 ps=1.27 w=1 l=0.15
X4 VPWR A Y VPB sky130_fd_pr__pfet_01v8_hvt ad=0.135 pd=1.27 as=0.135 ps=1.27 w=1 l=0.15
X5 a_27_47# A Y VNB sky130_fd_pr__nfet_01v8 ad=0.08775 pd=0.92 as=0.08775 ps=0.92 w=0.65 l=0.15
X6 a_27_47# B a_277_47# VNB sky130_fd_pr__nfet_01v8 ad=0.169 pd=1.82 as=0.08775 ps=0.92 w=0.65 l=0.15
X7 VPWR C Y VPB sky130_fd_pr__pfet_01v8_hvt ad=0.31 pd=2.62 as=0.135 ps=1.27 w=1 l=0.15
X8 Y C VPWR VPB sky130_fd_pr__pfet_01v8_hvt ad=0.135 pd=1.27 as=0.26 ps=2.52 w=1 l=0.15
X9 a_277_47# B a_27_47# VNB sky130_fd_pr__nfet_01v8 ad=0.08775 pd=0.92 as=0.08775 ps=0.92 w=0.65 l=0.15
X10 Y A VPWR VPB sky130_fd_pr__pfet_01v8_hvt ad=0.135 pd=1.27 as=0.26 ps=2.52 w=1 l=0.15
X11 Y A a_27_47# VNB sky130_fd_pr__nfet_01v8 ad=0.08775 pd=0.92 as=0.169 ps=1.82 w=0.65 l=0.15
.ends

.subckt sky130_fd_sc_hd__o32ai_2 A1 B1 A2 A3 Y B2 VGND VPWR VPB VNB
X0 VGND A1 a_27_47# VNB sky130_fd_pr__nfet_01v8 ad=0.08775 pd=0.92 as=0.25675 ps=1.44 w=0.65 l=0.15
X1 a_27_47# A3 VGND VNB sky130_fd_pr__nfet_01v8 ad=0.08775 pd=0.92 as=0.25675 ps=1.44 w=0.65 l=0.15
X2 a_475_297# A2 a_729_297# VPB sky130_fd_pr__pfet_01v8_hvt ad=0.28 pd=2.56 as=0.135 ps=1.27 w=1 l=0.15
X3 a_729_297# A1 VPWR VPB sky130_fd_pr__pfet_01v8_hvt ad=0.135 pd=1.27 as=0.26 ps=2.52 w=1 l=0.15
X4 VPWR A1 a_729_297# VPB sky130_fd_pr__pfet_01v8_hvt ad=0.28 pd=2.56 as=0.135 ps=1.27 w=1 l=0.15
X5 a_27_47# A2 VGND VNB sky130_fd_pr__nfet_01v8 ad=0.25675 pd=1.44 as=0.08775 ps=0.92 w=0.65 l=0.15
X6 a_27_297# B1 VPWR VPB sky130_fd_pr__pfet_01v8_hvt ad=0.26 pd=2.52 as=0.135 ps=1.27 w=1 l=0.15
X7 a_729_297# A2 a_475_297# VPB sky130_fd_pr__pfet_01v8_hvt ad=0.135 pd=1.27 as=0.135 ps=1.27 w=1 l=0.15
X8 VPWR B1 a_27_297# VPB sky130_fd_pr__pfet_01v8_hvt ad=0.135 pd=1.27 as=0.135 ps=1.27 w=1 l=0.15
X9 VGND A2 a_27_47# VNB sky130_fd_pr__nfet_01v8 ad=0.08775 pd=0.92 as=0.08775 ps=0.92 w=0.65 l=0.15
X10 a_27_297# B2 Y VPB sky130_fd_pr__pfet_01v8_hvt ad=0.135 pd=1.27 as=0.135 ps=1.27 w=1 l=0.15
X11 a_27_47# B2 Y VNB sky130_fd_pr__nfet_01v8 ad=0.08775 pd=0.92 as=0.08775 ps=0.92 w=0.65 l=0.15
X12 a_27_47# B1 Y VNB sky130_fd_pr__nfet_01v8 ad=0.08775 pd=0.92 as=0.08775 ps=0.92 w=0.65 l=0.15
X13 a_475_297# A3 Y VPB sky130_fd_pr__pfet_01v8_hvt ad=0.135 pd=1.27 as=0.135 ps=1.27 w=1 l=0.15
X14 Y A3 a_475_297# VPB sky130_fd_pr__pfet_01v8_hvt ad=0.135 pd=1.27 as=0.28 ps=2.56 w=1 l=0.15
X15 Y B1 a_27_47# VNB sky130_fd_pr__nfet_01v8 ad=0.08775 pd=0.92 as=0.08775 ps=0.92 w=0.65 l=0.15
X16 a_27_47# A1 VGND VNB sky130_fd_pr__nfet_01v8 ad=0.2275 pd=2 as=0.08775 ps=0.92 w=0.65 l=0.15
X17 VGND A3 a_27_47# VNB sky130_fd_pr__nfet_01v8 ad=0.25675 pd=1.44 as=0.08775 ps=0.92 w=0.65 l=0.15
X18 Y B2 a_27_297# VPB sky130_fd_pr__pfet_01v8_hvt ad=0.135 pd=1.27 as=0.26 ps=2.52 w=1 l=0.15
X19 Y B2 a_27_47# VNB sky130_fd_pr__nfet_01v8 ad=0.08775 pd=0.92 as=0.169 ps=1.82 w=0.65 l=0.15
.ends

.subckt sky130_fd_sc_hd__o21ba_2 B1_N A1 X A2 VGND VPWR VPB VNB
X0 VGND B1_N a_27_93# VNB sky130_fd_pr__nfet_01v8 ad=0.097 pd=0.975 as=0.1092 ps=1.36 w=0.42 l=0.15
X1 VGND A2 a_478_47# VNB sky130_fd_pr__nfet_01v8 ad=0.08775 pd=0.92 as=0.105625 ps=0.975 w=0.65 l=0.15
X2 a_478_47# a_27_93# a_174_21# VNB sky130_fd_pr__nfet_01v8 ad=0.105625 pd=0.975 as=0.169 ps=1.82 w=0.65 l=0.15
X3 a_478_47# A1 VGND VNB sky130_fd_pr__nfet_01v8 ad=0.169 pd=1.82 as=0.08775 ps=0.92 w=0.65 l=0.15
X4 X a_174_21# VGND VNB sky130_fd_pr__nfet_01v8 ad=0.08775 pd=0.92 as=0.097 ps=0.975 w=0.65 l=0.15
X5 VPWR a_174_21# X VPB sky130_fd_pr__pfet_01v8_hvt ad=0.395 pd=1.79 as=0.135 ps=1.27 w=1 l=0.15
X6 X a_174_21# VPWR VPB sky130_fd_pr__pfet_01v8_hvt ad=0.135 pd=1.27 as=0.14575 ps=1.335 w=1 l=0.15
X7 VPWR A1 a_574_297# VPB sky130_fd_pr__pfet_01v8_hvt ad=0.28 pd=2.56 as=0.105 ps=1.21 w=1 l=0.15
X8 VGND a_174_21# X VNB sky130_fd_pr__nfet_01v8 ad=0.169 pd=1.82 as=0.08775 ps=0.92 w=0.65 l=0.15
X9 VPWR B1_N a_27_93# VPB sky130_fd_pr__pfet_01v8_hvt ad=0.14575 pd=1.335 as=0.1092 ps=1.36 w=0.42 l=0.15
X10 a_574_297# A2 a_174_21# VPB sky130_fd_pr__pfet_01v8_hvt ad=0.105 pd=1.21 as=0.165 ps=1.33 w=1 l=0.15
X11 a_174_21# a_27_93# VPWR VPB sky130_fd_pr__pfet_01v8_hvt ad=0.165 pd=1.33 as=0.395 ps=1.79 w=1 l=0.15
.ends

.subckt sky130_fd_sc_hd__or4bb_2 A X B D_N C_N VPWR VGND VPB VNB
X0 a_398_413# a_206_93# a_316_413# VPB sky130_fd_pr__pfet_01v8_hvt ad=0.1215 pd=1.33 as=0.1092 ps=1.36 w=0.42 l=0.15
X1 VPWR a_316_413# X VPB sky130_fd_pr__pfet_01v8_hvt ad=0.285 pd=2.57 as=0.135 ps=1.27 w=1 l=0.15
X2 X a_316_413# VGND VNB sky130_fd_pr__nfet_01v8 ad=0.08775 pd=0.92 as=0.101875 ps=0.99 w=0.65 l=0.15
X3 X a_316_413# VPWR VPB sky130_fd_pr__pfet_01v8_hvt ad=0.135 pd=1.27 as=0.14825 ps=1.34 w=1 l=0.15
X4 VGND C_N a_27_410# VNB sky130_fd_pr__nfet_01v8 ad=0.06195 pd=0.715 as=0.1092 ps=1.36 w=0.42 l=0.15
X5 VPWR C_N a_27_410# VPB sky130_fd_pr__pfet_01v8_hvt ad=0.1226 pd=1.32 as=0.1092 ps=1.36 w=0.42 l=0.15
X6 VGND a_27_410# a_316_413# VNB sky130_fd_pr__nfet_01v8 ad=0.0567 pd=0.69 as=0.06405 ps=0.725 w=0.42 l=0.15
X7 VGND A a_316_413# VNB sky130_fd_pr__nfet_01v8 ad=0.101875 pd=0.99 as=0.0567 ps=0.69 w=0.42 l=0.15
X8 VGND a_316_413# X VNB sky130_fd_pr__nfet_01v8 ad=0.18525 pd=1.87 as=0.08775 ps=0.92 w=0.65 l=0.15
X9 a_566_297# B a_494_297# VPB sky130_fd_pr__pfet_01v8_hvt ad=0.05985 pd=0.705 as=0.0441 ps=0.63 w=0.42 l=0.15
X10 a_206_93# D_N VGND VNB sky130_fd_pr__nfet_01v8 ad=0.1092 pd=1.36 as=0.06195 ps=0.715 w=0.42 l=0.15
X11 a_316_413# B VGND VNB sky130_fd_pr__nfet_01v8 ad=0.0567 pd=0.69 as=0.0567 ps=0.69 w=0.42 l=0.15
X12 a_206_93# D_N VPWR VPB sky130_fd_pr__pfet_01v8_hvt ad=0.1176 pd=1.4 as=0.1226 ps=1.32 w=0.42 l=0.15
X13 a_494_297# a_27_410# a_398_413# VPB sky130_fd_pr__pfet_01v8_hvt ad=0.0441 pd=0.63 as=0.1215 ps=1.33 w=0.42 l=0.15
X14 a_316_413# a_206_93# VGND VNB sky130_fd_pr__nfet_01v8 ad=0.06405 pd=0.725 as=0.1092 ps=1.36 w=0.42 l=0.15
X15 VPWR A a_566_297# VPB sky130_fd_pr__pfet_01v8_hvt ad=0.14825 pd=1.34 as=0.05985 ps=0.705 w=0.42 l=0.15
.ends

.subckt puzzle I O[0] O[1] O[2] O[3] O[4] O[5] O[6] O[7] clk enable rst_n success
+ VGND VPWR
Xsky130_fd_sc_hd__nor4_2_0 sky130_fd_sc_hd__or4b_2_2/C sky130_fd_sc_hd__or4b_2_3/C
+ sky130_fd_sc_hd__nor4_2_0/Y sky130_fd_sc_hd__or4b_2_3/A sky130_fd_sc_hd__or4b_2_3/B
+ VGND VPWR sky130_fd_sc_hd__nor4_2_0/VPB VGND sky130_fd_sc_hd__nor4_2
Xsky130_fd_sc_hd__or2_2_8 sky130_fd_sc_hd__or2_2_8/B sky130_fd_sc_hd__or2_2_8/X sky130_fd_sc_hd__or2_2_9/B
+ VPWR VGND sky130_fd_sc_hd__or2_2_8/VPB VGND sky130_fd_sc_hd__or2_2
Xsky130_fd_sc_hd__and2b_2_3 sky130_fd_sc_hd__and4_2_1/A sky130_fd_sc_hd__and2b_2_3/B
+ sky130_fd_sc_hd__nand4_2_1/C VPWR VGND VPWR VGND sky130_fd_sc_hd__and2b_2
Xsky130_fd_sc_hd__o31ai_2_1 sky130_fd_sc_hd__or3_2_3/A sky130_fd_sc_hd__o31ai_2_1/Y
+ sky130_fd_sc_hd__nor2_2_5/A sky130_fd_sc_hd__or2_2_2/A sky130_fd_sc_hd__or3_2_3/B
+ VGND VPWR VPWR VGND sky130_fd_sc_hd__o31ai_2
Xsky130_fd_sc_hd__decap_3_14 VPWR VGND sky130_fd_sc_hd__decap_3_14/VPB VGND sky130_fd_sc_hd__decap_3
Xsky130_fd_sc_hd__decap_3_36 VPWR VGND sky130_fd_sc_hd__decap_3_36/VPB VGND sky130_fd_sc_hd__decap_3
Xsky130_fd_sc_hd__decap_3_25 VPWR VGND sky130_fd_sc_hd__decap_3_25/VPB VGND sky130_fd_sc_hd__decap_3
Xsky130_fd_sc_hd__decap_3_47 VPWR VGND sky130_fd_sc_hd__decap_3_58/VPB VGND sky130_fd_sc_hd__decap_3
Xsky130_fd_sc_hd__decap_3_58 VPWR VGND sky130_fd_sc_hd__decap_3_58/VPB VGND sky130_fd_sc_hd__decap_3
Xsky130_fd_sc_hd__decap_3_69 VPWR VGND sky130_fd_sc_hd__decap_3_69/VPB VGND sky130_fd_sc_hd__decap_3
Xsky130_fd_sc_hd__a31o_2_17 sky130_fd_sc_hd__a31o_2_17/X sky130_fd_sc_hd__nand4_2_4/C
+ sky130_fd_sc_hd__nand4_2_4/D I sky130_fd_sc_hd__inv_2_7/A VGND VPWR VPWR VGND sky130_fd_sc_hd__a31o_2
Xsky130_fd_sc_hd__and3_2_20 sky130_fd_sc_hd__o31a_2_10/X O[3] sky130_fd_sc_hd__or2_2_11/B
+ sky130_fd_sc_hd__and3_2_25/C VPWR VGND VPWR VGND sky130_fd_sc_hd__and3_2
Xsky130_fd_sc_hd__nand4_2_12 sky130_fd_sc_hd__inv_2_7/A I sky130_fd_sc_hd__o21a_2_27/A2
+ sky130_fd_sc_hd__nand4_2_12/D sky130_fd_sc_hd__nand4_2_12/C VGND VPWR VPWR VGND
+ sky130_fd_sc_hd__nand4_2
Xsky130_fd_sc_hd__or3_2_17 sky130_fd_sc_hd__or3_2_17/A sky130_fd_sc_hd__or3_2_17/B
+ sky130_fd_sc_hd__or3_2_17/X sky130_fd_sc_hd__or3_2_17/C VGND VPWR VPWR VGND sky130_fd_sc_hd__or3_2
Xsky130_fd_sc_hd__a31o_2_9 sky130_fd_sc_hd__a31o_2_9/X sky130_fd_sc_hd__nor3_2_2/A
+ sky130_fd_sc_hd__and4_2_4/D sky130_fd_sc_hd__and4_2_3/C sky130_fd_sc_hd__inv_2_10/A
+ VGND VPWR VPWR VGND sky130_fd_sc_hd__a31o_2
Xsky130_fd_sc_hd__xnor2_2_24 sky130_fd_sc_hd__nor3b_2_0/B sky130_fd_sc_hd__xor2_2_16/A
+ sky130_fd_sc_hd__xor2_2_19/X VGND VPWR VPWR VGND sky130_fd_sc_hd__xnor2_2
Xsky130_fd_sc_hd__and4bb_2_7 sky130_fd_sc_hd__or4b_2_3/A sky130_fd_sc_hd__or4b_2_2/C
+ sky130_fd_sc_hd__or4b_2_3/C sky130_fd_sc_hd__nand4_2_4/D sky130_fd_sc_hd__or4b_2_3/B
+ VGND VPWR VPWR VGND sky130_fd_sc_hd__and4bb_2
Xsky130_fd_sc_hd__xnor2_2_13 sky130_fd_sc_hd__xnor2_2_13/Y sky130_fd_sc_hd__xor2_2_17/B
+ sky130_fd_sc_hd__a31o_2_15/X VGND VPWR VPWR VGND sky130_fd_sc_hd__xnor2_2
Xsky130_fd_sc_hd__clkbuf_8_15 sky130_fd_sc_hd__dfrtp_2_8/CLK sky130_fd_sc_hd__clkbuf_8_9/A
+ VGND VPWR VPWR VGND sky130_fd_sc_hd__clkbuf_8
Xsky130_fd_sc_hd__nor3b_2_2 sky130_fd_sc_hd__nor3_2_3/B sky130_fd_sc_hd__nor3b_2_2/Y
+ sky130_fd_sc_hd__nor3_2_3/A sky130_fd_sc_hd__nor3_2_3/C VGND VPWR VPWR VGND sky130_fd_sc_hd__nor3b_2
Xsky130_fd_sc_hd__clkbuf_8_1 sky130_fd_sc_hd__clkbuf_8_1/X sky130_fd_sc_hd__clkbuf_8_9/A
+ VGND VPWR VPWR VGND sky130_fd_sc_hd__clkbuf_8
Xsky130_fd_sc_hd__mux2_1_4 sky130_fd_sc_hd__mux2_1_4/S sky130_fd_sc_hd__or2_2_4/A
+ sky130_fd_sc_hd__or3_2_4/B sky130_fd_sc_hd__mux2_1_4/X VGND VPWR VPWR VGND sky130_fd_sc_hd__mux2_1
Xsky130_fd_sc_hd__a21o_2_8 sky130_fd_sc_hd__xor2_2_8/A sky130_fd_sc_hd__nor2_2_19/Y
+ sky130_fd_sc_hd__xor2_2_2/A sky130_fd_sc_hd__a21o_2_8/A2 VGND VPWR VPWR VGND sky130_fd_sc_hd__a21o_2
Xsky130_fd_sc_hd__a211oi_2_0 sky130_fd_sc_hd__inv_2_9/A sky130_fd_sc_hd__xor2_2_11/B
+ sky130_fd_sc_hd__a21oi_2_13/Y sky130_fd_sc_hd__dfrtp_2_43/D sky130_fd_sc_hd__inv_2_7/A
+ VPWR VGND VPWR VGND sky130_fd_sc_hd__a211oi_2
Xsky130_fd_sc_hd__nor4_2_1 sky130_fd_sc_hd__or4_2_4/D sky130_fd_sc_hd__or4_2_4/C sky130_fd_sc_hd__nor4_2_1/Y
+ sky130_fd_sc_hd__or4_2_4/B sky130_fd_sc_hd__or4_2_4/A VGND VPWR sky130_fd_sc_hd__nor4_2_1/VPB
+ VGND sky130_fd_sc_hd__nor4_2
Xsky130_fd_sc_hd__a22oi_2_0 sky130_fd_sc_hd__or3b_2_0/A sky130_fd_sc_hd__inv_2_13/Y
+ sky130_fd_sc_hd__or2_2_9/X sky130_fd_sc_hd__nand2_2_29/Y sky130_fd_sc_hd__a22oi_2_0/Y
+ VPWR VGND VPWR VGND sky130_fd_sc_hd__a22oi_2
Xsky130_fd_sc_hd__or2_2_9 sky130_fd_sc_hd__or2_2_9/B sky130_fd_sc_hd__or2_2_9/X sky130_fd_sc_hd__or2_2_9/A
+ VPWR VGND VPWR VGND sky130_fd_sc_hd__or2_2
Xsky130_fd_sc_hd__o221a_2_0 sky130_fd_sc_hd__or4_2_0/A sky130_fd_sc_hd__o21ai_2_2/Y
+ sky130_fd_sc_hd__o221a_2_0/X sky130_fd_sc_hd__o21a_2_1/X sky130_fd_sc_hd__or4_2_0/B
+ sky130_fd_sc_hd__or3_2_2/C VGND VPWR VPWR VGND sky130_fd_sc_hd__o221a_2
Xsky130_fd_sc_hd__and2b_2_4 sky130_fd_sc_hd__and4_2_1/D sky130_fd_sc_hd__o21a_2_8/A1
+ sky130_fd_sc_hd__nand4_2_2/C VPWR VGND sky130_fd_sc_hd__dfrtp_2_5/VPB VGND sky130_fd_sc_hd__and2b_2
Xsky130_fd_sc_hd__and4_2_0 sky130_fd_sc_hd__and4_2_0/X sky130_fd_sc_hd__and4_2_0/C
+ sky130_fd_sc_hd__and4_2_0/A sky130_fd_sc_hd__and4_2_0/B sky130_fd_sc_hd__and4_2_0/D
+ VGND VPWR sky130_fd_sc_hd__and4_2_0/VPB VGND sky130_fd_sc_hd__and4_2
Xsky130_fd_sc_hd__decap_3_15 VPWR VGND sky130_fd_sc_hd__decap_3_16/VPB VGND sky130_fd_sc_hd__decap_3
Xsky130_fd_sc_hd__decap_3_26 VPWR VGND sky130_fd_sc_hd__decap_3_35/VPB VGND sky130_fd_sc_hd__decap_3
Xsky130_fd_sc_hd__decap_3_48 VPWR VGND sky130_fd_sc_hd__decap_3_51/VPB VGND sky130_fd_sc_hd__decap_3
Xsky130_fd_sc_hd__decap_3_37 VPWR VGND VPWR VGND sky130_fd_sc_hd__decap_3
Xsky130_fd_sc_hd__decap_3_59 VPWR VGND sky130_fd_sc_hd__decap_3_75/VPB VGND sky130_fd_sc_hd__decap_3
Xsky130_fd_sc_hd__a31o_2_18 sky130_fd_sc_hd__a31o_2_18/X sky130_fd_sc_hd__nand4_2_7/C
+ sky130_fd_sc_hd__nor4_2_1/Y I sky130_fd_sc_hd__inv_2_7/A VGND VPWR sky130_fd_sc_hd__nor4_2_1/VPB
+ VGND sky130_fd_sc_hd__a31o_2
Xsky130_fd_sc_hd__and3_2_10 sky130_fd_sc_hd__and3_2_10/B sky130_fd_sc_hd__or4b_2_8/C
+ sky130_fd_sc_hd__and3_2_10/A sky130_fd_sc_hd__and4_2_4/B VPWR VGND VPWR VGND sky130_fd_sc_hd__and3_2
Xsky130_fd_sc_hd__and3_2_21 sky130_fd_sc_hd__o31a_2_5/X O[4] sky130_fd_sc_hd__or2_2_11/B
+ sky130_fd_sc_hd__and3_2_25/C VPWR VGND VPWR VGND sky130_fd_sc_hd__and3_2
Xsky130_fd_sc_hd__nand4_2_13 sky130_fd_sc_hd__inv_2_7/A I sky130_fd_sc_hd__o21a_2_25/A2
+ sky130_fd_sc_hd__nand4_2_13/D sky130_fd_sc_hd__nand4_2_13/C VGND VPWR VPWR VGND
+ sky130_fd_sc_hd__nand4_2
Xsky130_fd_sc_hd__xnor2_2_25 sky130_fd_sc_hd__nor2_2_46/B sky130_fd_sc_hd__a22o_2_4/B2
+ sky130_fd_sc_hd__xor2_2_17/X VGND VPWR VPWR VGND sky130_fd_sc_hd__xnor2_2
Xsky130_fd_sc_hd__and4bb_2_8 sky130_fd_sc_hd__or4b_2_3/B sky130_fd_sc_hd__or4b_2_2/C
+ sky130_fd_sc_hd__or4b_2_3/C sky130_fd_sc_hd__nand4_2_6/D sky130_fd_sc_hd__or4b_2_3/A
+ VGND VPWR VPWR VGND sky130_fd_sc_hd__and4bb_2
Xsky130_fd_sc_hd__xnor2_2_14 sky130_fd_sc_hd__xnor2_2_14/Y sky130_fd_sc_hd__xor2_2_16/A
+ sky130_fd_sc_hd__xnor2_2_14/B VGND VPWR VPWR VGND sky130_fd_sc_hd__xnor2_2
Xsky130_fd_sc_hd__nor3b_2_3 sky130_fd_sc_hd__nor3_2_3/C sky130_fd_sc_hd__nor3b_2_3/Y
+ sky130_fd_sc_hd__nor3_2_3/A sky130_fd_sc_hd__nor3_2_3/B VGND VPWR VPWR VGND sky130_fd_sc_hd__nor3b_2
Xsky130_fd_sc_hd__clkbuf_8_2 sky130_fd_sc_hd__clkbuf_8_2/X sky130_fd_sc_hd__clkbuf_8_9/A
+ VGND VPWR VPWR VGND sky130_fd_sc_hd__clkbuf_8
Xsky130_fd_sc_hd__mux2_1_5 sky130_fd_sc_hd__xor2_2_7/A sky130_fd_sc_hd__mux2_1_5/A1
+ sky130_fd_sc_hd__and3_2_7/X sky130_fd_sc_hd__mux2_1_5/X VGND VPWR VPWR VGND sky130_fd_sc_hd__mux2_1
Xsky130_fd_sc_hd__a21o_2_9 sky130_fd_sc_hd__a21o_2_9/X sky130_fd_sc_hd__xor2_2_4/A
+ sky130_fd_sc_hd__xor2_2_9/A sky130_fd_sc_hd__inv_2_5/A VGND VPWR VPWR VGND sky130_fd_sc_hd__a21o_2
Xsky130_fd_sc_hd__a211oi_2_1 sky130_fd_sc_hd__a32o_2_3/B1 sky130_fd_sc_hd__or4b_2_8/A
+ sky130_fd_sc_hd__or4b_2_8/C sky130_fd_sc_hd__nor3_2_3/A sky130_fd_sc_hd__inv_2_22/Y
+ VPWR VGND VPWR VGND sky130_fd_sc_hd__a211oi_2
Xsky130_fd_sc_hd__o221a_2_1 sky130_fd_sc_hd__xnor2_2_21/Y sky130_fd_sc_hd__or2_2_10/X
+ sky130_fd_sc_hd__o221a_2_1/X sky130_fd_sc_hd__nor2_2_46/A sky130_fd_sc_hd__o21ai_2_3/Y
+ sky130_fd_sc_hd__xor2_2_16/A VGND VPWR VPWR VGND sky130_fd_sc_hd__o221a_2
Xsky130_fd_sc_hd__and2b_2_5 sky130_fd_sc_hd__xor2_2_6/B sky130_fd_sc_hd__o22ai_2_0/Y
+ sky130_fd_sc_hd__and4bb_2_0/X VPWR VGND VPWR VGND sky130_fd_sc_hd__and2b_2
Xsky130_fd_sc_hd__a21oi_2_0 sky130_fd_sc_hd__or4_2_0/A sky130_fd_sc_hd__nor2_2_3/B
+ sky130_fd_sc_hd__or3_2_3/B sky130_fd_sc_hd__a32o_2_1/B2 VGND VPWR VPWR VGND sky130_fd_sc_hd__a21oi_2
Xsky130_fd_sc_hd__and4_2_1 sky130_fd_sc_hd__and4_2_1/X sky130_fd_sc_hd__and4_2_1/C
+ sky130_fd_sc_hd__and4_2_1/A sky130_fd_sc_hd__and4_2_1/B sky130_fd_sc_hd__and4_2_1/D
+ VGND VPWR sky130_fd_sc_hd__and4_2_1/VPB VGND sky130_fd_sc_hd__and4_2
Xsky130_fd_sc_hd__decap_3_16 VPWR VGND sky130_fd_sc_hd__decap_3_16/VPB VGND sky130_fd_sc_hd__decap_3
Xsky130_fd_sc_hd__decap_3_27 VPWR VGND sky130_fd_sc_hd__decap_3_27/VPB VGND sky130_fd_sc_hd__decap_3
Xsky130_fd_sc_hd__decap_3_38 VPWR VGND sky130_fd_sc_hd__decap_3_5/VPB VGND sky130_fd_sc_hd__decap_3
Xsky130_fd_sc_hd__decap_3_49 VPWR VGND sky130_fd_sc_hd__decap_3_56/VPB VGND sky130_fd_sc_hd__decap_3
Xsky130_fd_sc_hd__a31o_2_19 sky130_fd_sc_hd__a31o_2_19/X sky130_fd_sc_hd__nand4_2_8/C
+ sky130_fd_sc_hd__nand4_2_8/D I sky130_fd_sc_hd__inv_2_7/A VGND VPWR VPWR VGND sky130_fd_sc_hd__a31o_2
Xsky130_fd_sc_hd__o211a_2_0 sky130_fd_sc_hd__xor2_2_4/A sky130_fd_sc_hd__xor2_2_9/A
+ sky130_fd_sc_hd__xor2_2_0/B sky130_fd_sc_hd__xor2_2_7/A sky130_fd_sc_hd__o211a_2_0/X
+ VPWR VGND VPWR VGND sky130_fd_sc_hd__o211a_2
Xsky130_fd_sc_hd__and3_2_22 sky130_fd_sc_hd__o31a_2_8/X O[5] sky130_fd_sc_hd__or2_2_11/B
+ sky130_fd_sc_hd__and3_2_25/C VPWR VGND sky130_fd_sc_hd__and3_2_22/VPB VGND sky130_fd_sc_hd__and3_2
Xsky130_fd_sc_hd__and3_2_11 sky130_fd_sc_hd__and4_2_3/B sky130_fd_sc_hd__and3_2_11/X
+ sky130_fd_sc_hd__and4_2_3/A sky130_fd_sc_hd__inv_2_10/A VPWR VGND VPWR VGND sky130_fd_sc_hd__and3_2
Xsky130_fd_sc_hd__nand4_2_14 sky130_fd_sc_hd__or2_2_9/B sky130_fd_sc_hd__or2_2_8/B
+ sky130_fd_sc_hd__and3_2_25/C sky130_fd_sc_hd__or3b_2_0/A sky130_fd_sc_hd__or2_2_9/A
+ VGND VPWR VPWR VGND sky130_fd_sc_hd__nand4_2
Xsky130_fd_sc_hd__and4bb_2_9 sky130_fd_sc_hd__or4_2_4/B sky130_fd_sc_hd__or4_2_4/C
+ sky130_fd_sc_hd__or4_2_4/D sky130_fd_sc_hd__nand4_2_9/D sky130_fd_sc_hd__or4_2_4/A
+ VGND VPWR VPWR VGND sky130_fd_sc_hd__and4bb_2
Xsky130_fd_sc_hd__xnor2_2_15 sky130_fd_sc_hd__a22o_2_9/A1 sky130_fd_sc_hd__a22o_2_4/B2
+ sky130_fd_sc_hd__a22o_2_22/X VGND VPWR VPWR VGND sky130_fd_sc_hd__xnor2_2
Xsky130_fd_sc_hd__xnor2_2_26 sky130_fd_sc_hd__nor2_2_40/A sky130_fd_sc_hd__xnor2_2_26/A
+ sky130_fd_sc_hd__xnor2_2_26/B VGND VPWR VPWR VGND sky130_fd_sc_hd__xnor2_2
Xsky130_fd_sc_hd__nor3b_2_4 sky130_fd_sc_hd__nor3_2_3/A sky130_fd_sc_hd__or3_2_17/B
+ sky130_fd_sc_hd__nor3_2_3/B sky130_fd_sc_hd__nor3_2_3/C VGND VPWR VPWR VGND sky130_fd_sc_hd__nor3b_2
Xsky130_fd_sc_hd__clkbuf_8_3 sky130_fd_sc_hd__clkbuf_8_3/X sky130_fd_sc_hd__clkbuf_8_9/A
+ VGND VPWR VPWR VGND sky130_fd_sc_hd__clkbuf_8
Xsky130_fd_sc_hd__mux2_1_6 sky130_fd_sc_hd__inv_2_7/Y sky130_fd_sc_hd__inv_2_8/Y sky130_fd_sc_hd__inv_2_9/A
+ sky130_fd_sc_hd__mux2_1_6/X VGND VPWR VPWR VGND sky130_fd_sc_hd__mux2_1
Xsky130_fd_sc_hd__a211oi_2_2 sky130_fd_sc_hd__or2_2_9/A sky130_fd_sc_hd__or2_2_8/B
+ sky130_fd_sc_hd__or2_2_9/B sky130_fd_sc_hd__or3_2_17/A sky130_fd_sc_hd__or3b_2_0/A
+ VPWR VGND VPWR VGND sky130_fd_sc_hd__a211oi_2
Xsky130_fd_sc_hd__o221a_2_2 sky130_fd_sc_hd__o221a_2_2/B2 sky130_fd_sc_hd__nor2_2_32/B
+ sky130_fd_sc_hd__o221a_2_2/X sky130_fd_sc_hd__nor2_2_32/Y sky130_fd_sc_hd__o221a_2_2/C1
+ sky130_fd_sc_hd__or2_2_8/X VGND VPWR VPWR VGND sky130_fd_sc_hd__o221a_2
Xsky130_fd_sc_hd__or4b_2_0 sky130_fd_sc_hd__or4b_2_3/C sky130_fd_sc_hd__or4b_2_3/A
+ sky130_fd_sc_hd__or4_2_1/C sky130_fd_sc_hd__or4b_2_2/C sky130_fd_sc_hd__or4b_2_3/B
+ VPWR VGND VPWR VGND sky130_fd_sc_hd__or4b_2
Xsky130_fd_sc_hd__and2b_2_6 sky130_fd_sc_hd__and2b_2_6/X sky130_fd_sc_hd__or3b_2_0/A
+ sky130_fd_sc_hd__or2_2_9/B VPWR VGND VPWR VGND sky130_fd_sc_hd__and2b_2
Xsky130_fd_sc_hd__a21oi_2_1 sky130_fd_sc_hd__or3_2_0/X sky130_fd_sc_hd__and3_2_0/C
+ sky130_fd_sc_hd__or2_2_4/A sky130_fd_sc_hd__o32a_2_0/A3 VGND VPWR VPWR VGND sky130_fd_sc_hd__a21oi_2
Xsky130_fd_sc_hd__decap_3_17 VPWR VGND sky130_fd_sc_hd__decap_3_19/VPB VGND sky130_fd_sc_hd__decap_3
Xsky130_fd_sc_hd__and4_2_2 sky130_fd_sc_hd__inv_2_5/A sky130_fd_sc_hd__xor2_2_0/B
+ sky130_fd_sc_hd__inv_2_9/A sky130_fd_sc_hd__inv_2_7/A sky130_fd_sc_hd__xor2_2_7/A
+ VGND VPWR VPWR VGND sky130_fd_sc_hd__and4_2
Xsky130_fd_sc_hd__decap_3_39 VPWR VGND sky130_fd_sc_hd__decap_3_43/VPB VGND sky130_fd_sc_hd__decap_3
Xsky130_fd_sc_hd__decap_3_28 VPWR VGND sky130_fd_sc_hd__decap_3_30/VPB VGND sky130_fd_sc_hd__decap_3
Xsky130_fd_sc_hd__o211a_2_1 sky130_fd_sc_hd__nor2_2_5/A sky130_fd_sc_hd__or2_2_4/A
+ sky130_fd_sc_hd__or2_2_2/A sky130_fd_sc_hd__or3_2_3/A sky130_fd_sc_hd__or3_2_4/C
+ VPWR VGND VPWR VGND sky130_fd_sc_hd__o211a_2
Xsky130_fd_sc_hd__and3_2_23 sky130_fd_sc_hd__o31a_2_3/X O[7] sky130_fd_sc_hd__or2_2_11/B
+ sky130_fd_sc_hd__and3_2_25/C VPWR VGND VPWR VGND sky130_fd_sc_hd__and3_2
Xsky130_fd_sc_hd__and3_2_12 sky130_fd_sc_hd__and3_2_12/B sky130_fd_sc_hd__and3_2_13/C
+ sky130_fd_sc_hd__and3_2_12/A sky130_fd_sc_hd__and3_2_12/C VPWR VGND VPWR VGND sky130_fd_sc_hd__and3_2
Xsky130_fd_sc_hd__xnor2_2_16 sky130_fd_sc_hd__xnor2_2_26/B sky130_fd_sc_hd__xor2_2_20/A
+ sky130_fd_sc_hd__xor2_2_17/B VGND VPWR VPWR VGND sky130_fd_sc_hd__xnor2_2
Xsky130_fd_sc_hd__xnor2_2_27 sky130_fd_sc_hd__o32a_2_2/A2 sky130_fd_sc_hd__or2_2_8/B
+ sky130_fd_sc_hd__and3_2_16/X VGND VPWR VPWR VGND sky130_fd_sc_hd__xnor2_2
Xsky130_fd_sc_hd__clkbuf_8_4 sky130_fd_sc_hd__clkbuf_8_4/X sky130_fd_sc_hd__clkbuf_8_9/A
+ VGND VPWR VPWR VGND sky130_fd_sc_hd__clkbuf_8
Xsky130_fd_sc_hd__dfrtp_2_80 sky130_fd_sc_hd__nand4_2_9/C rst_n sky130_fd_sc_hd__o21a_2_21/X
+ sky130_fd_sc_hd__clkbuf_8_9/X VGND VPWR VPWR VGND sky130_fd_sc_hd__dfrtp_2
Xsky130_fd_sc_hd__mux2_1_7 sky130_fd_sc_hd__inv_2_8/A sky130_fd_sc_hd__or2_2_7/X sky130_fd_sc_hd__mux2_1_7/A0
+ sky130_fd_sc_hd__mux2_1_7/X VGND VPWR VPWR VGND sky130_fd_sc_hd__mux2_1
Xsky130_fd_sc_hd__o2bb2a_2_0 sky130_fd_sc_hd__or4_2_4/C sky130_fd_sc_hd__xnor2_2_8/B
+ sky130_fd_sc_hd__xor2_2_1/B sky130_fd_sc_hd__xor2_2_9/A sky130_fd_sc_hd__nand2_2_2/Y
+ VGND VPWR VPWR VGND sky130_fd_sc_hd__o2bb2a_2
Xsky130_fd_sc_hd__or4b_2_1 sky130_fd_sc_hd__or4b_2_3/C sky130_fd_sc_hd__or4b_2_3/B
+ sky130_fd_sc_hd__or4_2_3/C sky130_fd_sc_hd__or4b_2_2/C sky130_fd_sc_hd__or4b_2_3/A
+ VPWR VGND VPWR VGND sky130_fd_sc_hd__or4b_2
Xsky130_fd_sc_hd__xor2_2_20 sky130_fd_sc_hd__xor2_2_20/X sky130_fd_sc_hd__xor2_2_20/B
+ sky130_fd_sc_hd__xor2_2_20/A VPWR VGND VPWR VGND sky130_fd_sc_hd__xor2_2
Xsky130_fd_sc_hd__and2b_2_7 sky130_fd_sc_hd__o31a_2_0/A1 sky130_fd_sc_hd__or2_2_9/B
+ sky130_fd_sc_hd__or2_2_9/A VPWR VGND sky130_fd_sc_hd__o31a_2_0/VPB VGND sky130_fd_sc_hd__and2b_2
Xsky130_fd_sc_hd__a21oi_2_2 sky130_fd_sc_hd__or4_2_0/A sky130_fd_sc_hd__o21ba_2_0/X
+ sky130_fd_sc_hd__or2_2_5/A sky130_fd_sc_hd__a21oi_2_2/Y VGND VPWR VPWR VGND sky130_fd_sc_hd__a21oi_2
Xsky130_fd_sc_hd__and4_2_3 sky130_fd_sc_hd__and4_2_3/X sky130_fd_sc_hd__and4_2_3/C
+ sky130_fd_sc_hd__and4_2_3/A sky130_fd_sc_hd__and4_2_3/B sky130_fd_sc_hd__nor3_2_2/Y
+ VGND VPWR VPWR VGND sky130_fd_sc_hd__and4_2
Xsky130_fd_sc_hd__decap_3_18 VPWR VGND sky130_fd_sc_hd__decap_3_36/VPB VGND sky130_fd_sc_hd__decap_3
Xsky130_fd_sc_hd__decap_3_29 VPWR VGND sky130_fd_sc_hd__decap_3_29/VPB VGND sky130_fd_sc_hd__decap_3
Xsky130_fd_sc_hd__o211a_2_2 sky130_fd_sc_hd__or3_2_7/X sky130_fd_sc_hd__nor2_2_20/Y
+ sky130_fd_sc_hd__a31o_2_5/X sky130_fd_sc_hd__o311a_2_0/X sky130_fd_sc_hd__or4b_2_3/B
+ VPWR VGND VPWR VGND sky130_fd_sc_hd__o211a_2
Xsky130_fd_sc_hd__and3_2_24 sky130_fd_sc_hd__o31a_2_7/X O[2] sky130_fd_sc_hd__or2_2_11/B
+ sky130_fd_sc_hd__and3_2_25/C VPWR VGND VPWR VGND sky130_fd_sc_hd__and3_2
Xsky130_fd_sc_hd__and3_2_13 sky130_fd_sc_hd__and4_2_6/X sky130_fd_sc_hd__and4b_2_3/D
+ sky130_fd_sc_hd__and4_2_5/X sky130_fd_sc_hd__and3_2_13/C VPWR VGND VPWR VGND sky130_fd_sc_hd__and3_2
Xsky130_fd_sc_hd__or2_2_10 sky130_fd_sc_hd__inv_2_7/A sky130_fd_sc_hd__or2_2_10/X
+ sky130_fd_sc_hd__or2_2_10/A VPWR VGND VPWR VGND sky130_fd_sc_hd__or2_2
Xsky130_fd_sc_hd__xnor2_2_28 sky130_fd_sc_hd__xnor2_2_28/Y sky130_fd_sc_hd__or2_2_9/A
+ sky130_fd_sc_hd__or3b_2_0/A VGND VPWR VPWR VGND sky130_fd_sc_hd__xnor2_2
Xsky130_fd_sc_hd__xnor2_2_17 sky130_fd_sc_hd__xnor2_2_26/A sky130_fd_sc_hd__xor2_2_14/B
+ sky130_fd_sc_hd__xor2_2_19/A VGND VPWR VPWR VGND sky130_fd_sc_hd__xnor2_2
Xsky130_fd_sc_hd__clkbuf_8_5 sky130_fd_sc_hd__clkbuf_8_5/X sky130_fd_sc_hd__clkbuf_8_9/A
+ VGND VPWR VPWR VGND sky130_fd_sc_hd__clkbuf_8
Xsky130_fd_sc_hd__dfrtp_2_70 sky130_fd_sc_hd__o21a_2_27/A1 rst_n sky130_fd_sc_hd__dfrtp_2_70/D
+ sky130_fd_sc_hd__clkbuf_8_11/X VGND VPWR VPWR VGND sky130_fd_sc_hd__dfrtp_2
Xsky130_fd_sc_hd__dfrtp_2_81 success rst_n sky130_fd_sc_hd__a32o_2_4/X sky130_fd_sc_hd__dfxtp_2_2/CLK
+ VGND VPWR VPWR VGND sky130_fd_sc_hd__dfrtp_2
Xsky130_fd_sc_hd__mux2_1_8 sky130_fd_sc_hd__inv_2_7/A sky130_fd_sc_hd__mux2_1_8/A1
+ sky130_fd_sc_hd__mux2_1_8/A0 sky130_fd_sc_hd__mux2_1_8/X VGND VPWR VPWR VGND sky130_fd_sc_hd__mux2_1
Xsky130_fd_sc_hd__or4b_2_2 sky130_fd_sc_hd__or4b_2_2/C sky130_fd_sc_hd__or4b_2_3/A
+ sky130_fd_sc_hd__or4_2_2/C sky130_fd_sc_hd__or4b_2_3/B sky130_fd_sc_hd__or4b_2_3/C
+ VPWR VGND VPWR VGND sky130_fd_sc_hd__or4b_2
Xsky130_fd_sc_hd__xor2_2_10 sky130_fd_sc_hd__xor2_2_10/X sky130_fd_sc_hd__and4_2_4/X
+ sky130_fd_sc_hd__or3_2_8/C VPWR VGND VPWR VGND sky130_fd_sc_hd__xor2_2
Xsky130_fd_sc_hd__and2b_2_8 sky130_fd_sc_hd__and3_2_10/B sky130_fd_sc_hd__or3_2_8/A
+ sky130_fd_sc_hd__and4_2_3/A VPWR VGND VPWR VGND sky130_fd_sc_hd__and2b_2
Xsky130_fd_sc_hd__a21oi_2_3 sky130_fd_sc_hd__or4_2_0/B sky130_fd_sc_hd__or3_2_4/X
+ sky130_fd_sc_hd__nand2_2_3/Y sky130_fd_sc_hd__or3_2_7/C VGND VPWR VPWR VGND sky130_fd_sc_hd__a21oi_2
Xsky130_fd_sc_hd__and4_2_4 sky130_fd_sc_hd__and4_2_4/X sky130_fd_sc_hd__inv_2_10/A
+ sky130_fd_sc_hd__nor3_2_2/B sky130_fd_sc_hd__and4_2_4/B sky130_fd_sc_hd__and4_2_4/D
+ VGND VPWR VPWR VGND sky130_fd_sc_hd__and4_2
Xsky130_fd_sc_hd__decap_3_19 VPWR VGND sky130_fd_sc_hd__decap_3_19/VPB VGND sky130_fd_sc_hd__decap_3
Xsky130_fd_sc_hd__nand2b_2_0 sky130_fd_sc_hd__or2_2_4/B sky130_fd_sc_hd__mux2_1_4/S
+ sky130_fd_sc_hd__and3_2_0/C VGND VPWR VPWR VGND sky130_fd_sc_hd__nand2b_2
Xsky130_fd_sc_hd__o211a_2_3 sky130_fd_sc_hd__nor2_2_20/Y sky130_fd_sc_hd__o211ai_2_0/Y
+ sky130_fd_sc_hd__a21o_2_3/X sky130_fd_sc_hd__xor2_2_5/X sky130_fd_sc_hd__or4b_2_3/A
+ VPWR VGND VPWR VGND sky130_fd_sc_hd__o211a_2
Xsky130_fd_sc_hd__and3_2_25 sky130_fd_sc_hd__o31a_2_9/X O[0] sky130_fd_sc_hd__or2_2_11/B
+ sky130_fd_sc_hd__and3_2_25/C VPWR VGND VPWR VGND sky130_fd_sc_hd__and3_2
Xsky130_fd_sc_hd__and3_2_14 sky130_fd_sc_hd__or4_2_4/A sky130_fd_sc_hd__xor2_2_11/B
+ sky130_fd_sc_hd__or4_2_4/B sky130_fd_sc_hd__inv_2_7/A VPWR VGND VPWR VGND sky130_fd_sc_hd__and3_2
Xsky130_fd_sc_hd__o211ai_2_0 sky130_fd_sc_hd__or2_2_5/A sky130_fd_sc_hd__mux2_1_2/X
+ sky130_fd_sc_hd__a211o_2_1/X sky130_fd_sc_hd__o211ai_2_0/Y sky130_fd_sc_hd__xor2_2_5/X
+ VGND VPWR VPWR VGND sky130_fd_sc_hd__o211ai_2
Xsky130_fd_sc_hd__or2_2_11 sky130_fd_sc_hd__or2_2_11/B sky130_fd_sc_hd__or2_2_11/X
+ sky130_fd_sc_hd__or2_2_11/A VPWR VGND VPWR VGND sky130_fd_sc_hd__or2_2
Xsky130_fd_sc_hd__xnor2_2_18 sky130_fd_sc_hd__xnor2_2_18/Y sky130_fd_sc_hd__or3_2_9/X
+ sky130_fd_sc_hd__xor2_2_15/X VGND VPWR VPWR VGND sky130_fd_sc_hd__xnor2_2
Xsky130_fd_sc_hd__clkbuf_8_6 sky130_fd_sc_hd__clkbuf_8_6/X sky130_fd_sc_hd__clkbuf_8_9/A
+ VGND VPWR VPWR VGND sky130_fd_sc_hd__clkbuf_8
Xsky130_fd_sc_hd__dfrtp_2_60 sky130_fd_sc_hd__nand4_2_7/C rst_n sky130_fd_sc_hd__o21a_2_19/X
+ sky130_fd_sc_hd__clkbuf_8_8/X VGND VPWR VPWR VGND sky130_fd_sc_hd__dfrtp_2
Xsky130_fd_sc_hd__dfrtp_2_82 sky130_fd_sc_hd__a32o_2_3/B1 rst_n sky130_fd_sc_hd__a32o_2_3/X
+ sky130_fd_sc_hd__dfxtp_2_2/CLK VGND VPWR VPWR VGND sky130_fd_sc_hd__dfrtp_2
Xsky130_fd_sc_hd__dfrtp_2_71 sky130_fd_sc_hd__nand4_2_8/C rst_n sky130_fd_sc_hd__o21a_2_23/X
+ sky130_fd_sc_hd__clkbuf_8_9/X VGND VPWR VPWR VGND sky130_fd_sc_hd__dfrtp_2
Xsky130_fd_sc_hd__mux2_1_9 sky130_fd_sc_hd__inv_2_7/A sky130_fd_sc_hd__mux2_1_9/A1
+ sky130_fd_sc_hd__mux2_1_9/A0 sky130_fd_sc_hd__mux2_1_9/X VGND VPWR VPWR VGND sky130_fd_sc_hd__mux2_1
Xsky130_fd_sc_hd__or4_2_0 sky130_fd_sc_hd__or4_2_0/C sky130_fd_sc_hd__or4_2_0/A sky130_fd_sc_hd__or4_2_0/X
+ sky130_fd_sc_hd__or4_2_0/B sky130_fd_sc_hd__or4_2_0/D VPWR VGND VPWR VGND sky130_fd_sc_hd__or4_2
Xsky130_fd_sc_hd__or4b_2_3 sky130_fd_sc_hd__or4b_2_3/C sky130_fd_sc_hd__or4b_2_3/A
+ sky130_fd_sc_hd__or4_2_5/C sky130_fd_sc_hd__or4b_2_3/B sky130_fd_sc_hd__or4b_2_2/C
+ VPWR VGND VPWR VGND sky130_fd_sc_hd__or4b_2
Xsky130_fd_sc_hd__xor2_2_11 sky130_fd_sc_hd__xor2_2_11/X sky130_fd_sc_hd__xor2_2_11/B
+ sky130_fd_sc_hd__or4_2_4/C VPWR VGND VPWR VGND sky130_fd_sc_hd__xor2_2
Xsky130_fd_sc_hd__and2b_2_9 sky130_fd_sc_hd__and2b_2_9/X sky130_fd_sc_hd__and2b_2_9/B
+ sky130_fd_sc_hd__and4_2_4/X VPWR VGND VPWR VGND sky130_fd_sc_hd__and2b_2
Xsky130_fd_sc_hd__clkbuf_4_0 sky130_fd_sc_hd__clkbuf_4_0/X sky130_fd_sc_hd__clkbuf_8_1/X
+ VGND VPWR VPWR VGND sky130_fd_sc_hd__clkbuf_4
Xsky130_fd_sc_hd__a21oi_2_4 sky130_fd_sc_hd__or3_2_5/X sky130_fd_sc_hd__and3_2_4/B
+ sky130_fd_sc_hd__and3_2_4/A sky130_fd_sc_hd__nor2_2_21/A VGND VPWR VPWR VGND sky130_fd_sc_hd__a21oi_2
Xsky130_fd_sc_hd__and4_2_5 sky130_fd_sc_hd__and4_2_5/X sky130_fd_sc_hd__and4_2_5/C
+ sky130_fd_sc_hd__and4_2_5/A sky130_fd_sc_hd__and4_2_5/B sky130_fd_sc_hd__and4_2_5/D
+ VGND VPWR VPWR VGND sky130_fd_sc_hd__and4_2
Xsky130_fd_sc_hd__nand2b_2_1 sky130_fd_sc_hd__o21a_2_4/A2 sky130_fd_sc_hd__nand2b_2_1/Y
+ sky130_fd_sc_hd__o21a_2_4/A1 VGND VPWR VPWR VGND sky130_fd_sc_hd__nand2b_2
Xsky130_fd_sc_hd__o211a_2_4 sky130_fd_sc_hd__nor2_2_20/Y sky130_fd_sc_hd__a221o_2_0/X
+ sky130_fd_sc_hd__o21ai_2_1/Y sky130_fd_sc_hd__xor2_2_5/X sky130_fd_sc_hd__or4b_2_3/C
+ VPWR VGND VPWR VGND sky130_fd_sc_hd__o211a_2
Xsky130_fd_sc_hd__and3_2_15 sky130_fd_sc_hd__or2_2_9/A sky130_fd_sc_hd__o31a_2_2/A1
+ sky130_fd_sc_hd__or3b_2_0/A sky130_fd_sc_hd__or2_2_9/B VPWR VGND VPWR VGND sky130_fd_sc_hd__and3_2
Xsky130_fd_sc_hd__or2_2_12 sky130_fd_sc_hd__or2_2_12/B sky130_fd_sc_hd__or2_2_12/X
+ sky130_fd_sc_hd__or2_2_12/A VPWR VGND VPWR VGND sky130_fd_sc_hd__or2_2
Xsky130_fd_sc_hd__xnor2_2_19 sky130_fd_sc_hd__xnor2_2_19/Y sky130_fd_sc_hd__xnor2_2_21/B
+ sky130_fd_sc_hd__xor2_2_19/X VGND VPWR VPWR VGND sky130_fd_sc_hd__xnor2_2
Xsky130_fd_sc_hd__clkbuf_8_7 sky130_fd_sc_hd__clkbuf_8_7/X sky130_fd_sc_hd__clkbuf_8_9/A
+ VGND VPWR VPWR VGND sky130_fd_sc_hd__clkbuf_8
Xsky130_fd_sc_hd__dfrtp_2_61 sky130_fd_sc_hd__or4_2_9/A rst_n sky130_fd_sc_hd__a21o_2_18/X
+ sky130_fd_sc_hd__dfxtp_2_3/CLK VGND VPWR VPWR VGND sky130_fd_sc_hd__dfrtp_2
Xsky130_fd_sc_hd__dfrtp_2_50 sky130_fd_sc_hd__xor2_2_19/A rst_n sky130_fd_sc_hd__o22a_2_3/X
+ sky130_fd_sc_hd__clkbuf_8_7/X VGND VPWR VPWR VGND sky130_fd_sc_hd__dfrtp_2
Xsky130_fd_sc_hd__dfrtp_2_83 sky130_fd_sc_hd__or2_2_11/B rst_n sky130_fd_sc_hd__or2_2_11/X
+ sky130_fd_sc_hd__dfxtp_2_2/CLK VGND VPWR VPWR VGND sky130_fd_sc_hd__dfrtp_2
Xsky130_fd_sc_hd__dfrtp_2_72 sky130_fd_sc_hd__inv_2_20/A rst_n sky130_fd_sc_hd__o21a_2_26/X
+ sky130_fd_sc_hd__clkbuf_8_11/X VGND VPWR VPWR VGND sky130_fd_sc_hd__dfrtp_2
Xsky130_fd_sc_hd__inv_2_20 sky130_fd_sc_hd__inv_2_20/A sky130_fd_sc_hd__or4_2_6/B
+ VPWR VGND VPWR VGND sky130_fd_sc_hd__inv_2
Xsky130_fd_sc_hd__or4_2_1 sky130_fd_sc_hd__or4_2_1/C sky130_fd_sc_hd__or4_2_1/A sky130_fd_sc_hd__or4_2_1/X
+ sky130_fd_sc_hd__or4_2_1/B sky130_fd_sc_hd__or4_2_1/D VPWR VGND VPWR VGND sky130_fd_sc_hd__or4_2
Xsky130_fd_sc_hd__or4b_2_4 sky130_fd_sc_hd__or4_2_4/C sky130_fd_sc_hd__or4_2_4/B sky130_fd_sc_hd__or4_2_9/C
+ sky130_fd_sc_hd__or4_2_4/D sky130_fd_sc_hd__or4_2_4/A VPWR VGND VPWR VGND sky130_fd_sc_hd__or4b_2
Xsky130_fd_sc_hd__xor2_2_12 sky130_fd_sc_hd__xor2_2_12/X sky130_fd_sc_hd__o31a_2_1/X
+ sky130_fd_sc_hd__xor2_2_14/B VPWR VGND VPWR VGND sky130_fd_sc_hd__xor2_2
Xsky130_fd_sc_hd__decap_3_200 VPWR VGND sky130_fd_sc_hd__decap_3_200/VPB VGND sky130_fd_sc_hd__decap_3
Xsky130_fd_sc_hd__clkbuf_4_1 sky130_fd_sc_hd__clkbuf_4_1/X sky130_fd_sc_hd__clkbuf_8_0/X
+ VGND VPWR VPWR VGND sky130_fd_sc_hd__clkbuf_4
Xsky130_fd_sc_hd__a21oi_2_5 sky130_fd_sc_hd__xor2_2_9/A sky130_fd_sc_hd__xor2_2_4/A
+ sky130_fd_sc_hd__xor2_2_0/B sky130_fd_sc_hd__a21oi_2_5/Y VGND VPWR VPWR VGND sky130_fd_sc_hd__a21oi_2
Xsky130_fd_sc_hd__and4_2_6 sky130_fd_sc_hd__and4_2_6/X sky130_fd_sc_hd__and4_2_6/C
+ sky130_fd_sc_hd__and4_2_6/A sky130_fd_sc_hd__and4_2_6/B sky130_fd_sc_hd__and4_2_6/D
+ VGND VPWR VPWR VGND sky130_fd_sc_hd__and4_2
Xsky130_fd_sc_hd__nand2b_2_2 sky130_fd_sc_hd__nand4_2_1/Y sky130_fd_sc_hd__nand2b_2_2/Y
+ sky130_fd_sc_hd__and2b_2_3/B VGND VPWR VPWR VGND sky130_fd_sc_hd__nand2b_2
Xsky130_fd_sc_hd__o211a_2_5 sky130_fd_sc_hd__nor2_2_20/Y sky130_fd_sc_hd__a211o_2_0/X
+ sky130_fd_sc_hd__mux2_1_3/X sky130_fd_sc_hd__xor2_2_5/X sky130_fd_sc_hd__or4b_2_2/C
+ VPWR VGND VPWR VGND sky130_fd_sc_hd__o211a_2
Xsky130_fd_sc_hd__a221oi_2_0 sky130_fd_sc_hd__or4_2_4/D sky130_fd_sc_hd__a41oi_2_0/Y
+ sky130_fd_sc_hd__inv_2_9/A sky130_fd_sc_hd__inv_2_7/A sky130_fd_sc_hd__and4_2_7/X
+ sky130_fd_sc_hd__dfrtp_2_45/D VGND VPWR VPWR VGND sky130_fd_sc_hd__a221oi_2
Xsky130_fd_sc_hd__and3_2_16 sky130_fd_sc_hd__or2_2_9/A sky130_fd_sc_hd__and3_2_16/X
+ sky130_fd_sc_hd__or3b_2_0/A sky130_fd_sc_hd__or2_2_9/B VPWR VGND VPWR VGND sky130_fd_sc_hd__and3_2
Xsky130_fd_sc_hd__clkbuf_8_8 sky130_fd_sc_hd__clkbuf_8_8/X sky130_fd_sc_hd__clkbuf_8_9/A
+ VGND VPWR VPWR VGND sky130_fd_sc_hd__clkbuf_8
Xsky130_fd_sc_hd__dfrtp_2_51 sky130_fd_sc_hd__xor2_2_19/B rst_n sky130_fd_sc_hd__a221o_2_2/X
+ sky130_fd_sc_hd__clkbuf_8_7/X VGND VPWR VPWR VGND sky130_fd_sc_hd__dfrtp_2
Xsky130_fd_sc_hd__dfrtp_2_40 sky130_fd_sc_hd__mux2_1_9/A0 rst_n sky130_fd_sc_hd__mux2_1_9/X
+ sky130_fd_sc_hd__clkbuf_8_5/X VGND VPWR VPWR VGND sky130_fd_sc_hd__dfrtp_2
Xsky130_fd_sc_hd__dfrtp_2_73 sky130_fd_sc_hd__nand4_2_13/C rst_n sky130_fd_sc_hd__o21a_2_25/X
+ sky130_fd_sc_hd__clkbuf_8_11/X VGND VPWR VPWR VGND sky130_fd_sc_hd__dfrtp_2
Xsky130_fd_sc_hd__dfrtp_2_62 sky130_fd_sc_hd__inv_2_18/A rst_n sky130_fd_sc_hd__o21a_2_20/X
+ sky130_fd_sc_hd__dfxtp_2_3/CLK VGND VPWR VPWR VGND sky130_fd_sc_hd__dfrtp_2
Xsky130_fd_sc_hd__inv_2_21 sky130_fd_sc_hd__or2_2_8/B sky130_fd_sc_hd__inv_2_21/Y
+ VPWR VGND VPWR VGND sky130_fd_sc_hd__inv_2
Xsky130_fd_sc_hd__inv_2_10 sky130_fd_sc_hd__inv_2_10/A sky130_fd_sc_hd__inv_2_10/Y
+ VPWR VGND VPWR VGND sky130_fd_sc_hd__inv_2
Xsky130_fd_sc_hd__nand2_2_0 sky130_fd_sc_hd__and3_2_1/C sky130_fd_sc_hd__or2_2_1/X
+ sky130_fd_sc_hd__or3_2_0/B VGND VPWR VPWR VGND sky130_fd_sc_hd__nand2_2
Xsky130_fd_sc_hd__or4_2_2 sky130_fd_sc_hd__or4_2_2/C sky130_fd_sc_hd__or4_2_2/A sky130_fd_sc_hd__or4_2_2/X
+ sky130_fd_sc_hd__or4_2_2/B sky130_fd_sc_hd__or4_2_2/D VPWR VGND VPWR VGND sky130_fd_sc_hd__or4_2
Xsky130_fd_sc_hd__or4b_2_5 sky130_fd_sc_hd__or4_2_4/D sky130_fd_sc_hd__or4_2_4/B sky130_fd_sc_hd__or4_2_8/C
+ sky130_fd_sc_hd__or4_2_4/A sky130_fd_sc_hd__or4_2_4/C VPWR VGND VPWR VGND sky130_fd_sc_hd__or4b_2
Xsky130_fd_sc_hd__xor2_2_13 sky130_fd_sc_hd__xor2_2_13/X sky130_fd_sc_hd__xor2_2_19/B
+ sky130_fd_sc_hd__or2_2_12/A VPWR VGND VPWR VGND sky130_fd_sc_hd__xor2_2
Xsky130_fd_sc_hd__decap_3_201 VPWR VGND sky130_fd_sc_hd__decap_3_201/VPB VGND sky130_fd_sc_hd__decap_3
Xsky130_fd_sc_hd__and4bb_2_10 sky130_fd_sc_hd__or4_2_4/D sky130_fd_sc_hd__or4_2_4/A
+ sky130_fd_sc_hd__or4_2_4/C sky130_fd_sc_hd__nand4_2_8/D sky130_fd_sc_hd__or4_2_4/B
+ VGND VPWR VPWR VGND sky130_fd_sc_hd__and4bb_2
Xsky130_fd_sc_hd__clkbuf_4_2 sky130_fd_sc_hd__clkbuf_4_2/X sky130_fd_sc_hd__clkbuf_8_4/X
+ VGND VPWR VPWR VGND sky130_fd_sc_hd__clkbuf_4
Xsky130_fd_sc_hd__a21oi_2_6 sky130_fd_sc_hd__or3_2_5/B sky130_fd_sc_hd__xnor2_2_4/A
+ sky130_fd_sc_hd__xor2_2_4/A sky130_fd_sc_hd__a21oi_2_6/Y VGND VPWR VPWR VGND sky130_fd_sc_hd__a21oi_2
Xsky130_fd_sc_hd__and4_2_7 sky130_fd_sc_hd__and4_2_7/X sky130_fd_sc_hd__or4_2_4/C
+ sky130_fd_sc_hd__or4_2_4/B sky130_fd_sc_hd__or4_2_4/A sky130_fd_sc_hd__inv_2_7/A
+ VGND VPWR VPWR VGND sky130_fd_sc_hd__and4_2
Xsky130_fd_sc_hd__nand2b_2_3 sky130_fd_sc_hd__o21a_2_8/A2 sky130_fd_sc_hd__nand2b_2_3/Y
+ sky130_fd_sc_hd__o21a_2_8/A1 VGND VPWR sky130_fd_sc_hd__dfrtp_2_5/VPB VGND sky130_fd_sc_hd__nand2b_2
Xsky130_fd_sc_hd__o211a_2_6 sky130_fd_sc_hd__or3_2_1/X sky130_fd_sc_hd__or4_2_0/B
+ sky130_fd_sc_hd__or3_2_4/B sky130_fd_sc_hd__nand2_2_3/Y sky130_fd_sc_hd__or3_2_7/B
+ VPWR VGND VPWR VGND sky130_fd_sc_hd__o211a_2
Xsky130_fd_sc_hd__and3_2_17 sky130_fd_sc_hd__inv_2_14/Y sky130_fd_sc_hd__and3_2_17/X
+ sky130_fd_sc_hd__or3b_2_0/A sky130_fd_sc_hd__and3_2_17/C VPWR VGND VPWR VGND sky130_fd_sc_hd__and3_2
Xsky130_fd_sc_hd__a21bo_2_0 sky130_fd_sc_hd__a32o_2_1/B2 sky130_fd_sc_hd__or2_2_3/X
+ sky130_fd_sc_hd__a31o_2_5/A2 sky130_fd_sc_hd__or3_2_0/B VGND VPWR VPWR VGND sky130_fd_sc_hd__a21bo_2
Xsky130_fd_sc_hd__a31oi_2_0 sky130_fd_sc_hd__nand2b_2_8/Y sky130_fd_sc_hd__and3b_2_0/C
+ sky130_fd_sc_hd__o31a_2_0/A2 sky130_fd_sc_hd__nor3_2_1/C sky130_fd_sc_hd__o32ai_2_0/B1
+ VPWR VGND VPWR VGND sky130_fd_sc_hd__a31oi_2
Xsky130_fd_sc_hd__decap_3_0 VPWR VGND sky130_fd_sc_hd__decap_3_2/VPB VGND sky130_fd_sc_hd__decap_3
Xsky130_fd_sc_hd__o311a_2_0 sky130_fd_sc_hd__o311a_2_0/X sky130_fd_sc_hd__or4_2_0/A
+ sky130_fd_sc_hd__and3_2_0/X sky130_fd_sc_hd__nor2_2_26/Y sky130_fd_sc_hd__or4_2_0/B
+ sky130_fd_sc_hd__o311a_2_0/C1 VPWR VGND VPWR VGND sky130_fd_sc_hd__o311a_2
Xsky130_fd_sc_hd__a21oi_2_10 sky130_fd_sc_hd__nor2_2_6/Y sky130_fd_sc_hd__xor2_2_7/X
+ sky130_fd_sc_hd__xor2_2_0/B sky130_fd_sc_hd__xor2_2_1/B VGND VPWR VPWR VGND sky130_fd_sc_hd__a21oi_2
Xsky130_fd_sc_hd__clkbuf_8_9 sky130_fd_sc_hd__clkbuf_8_9/X sky130_fd_sc_hd__clkbuf_8_9/A
+ VGND VPWR VPWR VGND sky130_fd_sc_hd__clkbuf_8
Xsky130_fd_sc_hd__dfrtp_2_52 sky130_fd_sc_hd__or4_2_5/A rst_n sky130_fd_sc_hd__a21o_2_13/X
+ sky130_fd_sc_hd__clkbuf_4_9/A VGND VPWR VPWR VGND sky130_fd_sc_hd__dfrtp_2
Xsky130_fd_sc_hd__dfrtp_2_30 sky130_fd_sc_hd__mux2_1_8/A1 rst_n sky130_fd_sc_hd__mux2_1_14/X
+ sky130_fd_sc_hd__clkbuf_8_2/X VGND VPWR VPWR VGND sky130_fd_sc_hd__dfrtp_2
Xsky130_fd_sc_hd__dfrtp_2_41 sky130_fd_sc_hd__a22o_2_2/A2 rst_n sky130_fd_sc_hd__mux2_1_13/X
+ sky130_fd_sc_hd__clkbuf_8_8/X VGND VPWR VPWR VGND sky130_fd_sc_hd__dfrtp_2
Xsky130_fd_sc_hd__dfrtp_2_74 sky130_fd_sc_hd__nand4_2_12/C rst_n sky130_fd_sc_hd__o21a_2_27/X
+ sky130_fd_sc_hd__clkbuf_8_11/X VGND VPWR VPWR VGND sky130_fd_sc_hd__dfrtp_2
Xsky130_fd_sc_hd__dfrtp_2_63 sky130_fd_sc_hd__o21a_2_23/A1 rst_n sky130_fd_sc_hd__dfrtp_2_63/D
+ sky130_fd_sc_hd__clkbuf_8_9/X VGND VPWR VPWR VGND sky130_fd_sc_hd__dfrtp_2
Xsky130_fd_sc_hd__inv_2_11 sky130_fd_sc_hd__inv_2_11/A sky130_fd_sc_hd__inv_2_23/A
+ VPWR VGND VPWR VGND sky130_fd_sc_hd__inv_2
Xsky130_fd_sc_hd__inv_2_22 success sky130_fd_sc_hd__inv_2_22/Y VPWR VGND VPWR VGND
+ sky130_fd_sc_hd__inv_2
Xsky130_fd_sc_hd__nand2_2_1 sky130_fd_sc_hd__and2_2_2/A sky130_fd_sc_hd__xor2_2_3/A
+ sky130_fd_sc_hd__or2_2_0/B VGND VPWR VPWR VGND sky130_fd_sc_hd__nand2_2
Xsky130_fd_sc_hd__or4_2_3 sky130_fd_sc_hd__or4_2_3/C sky130_fd_sc_hd__or4_2_3/A sky130_fd_sc_hd__or4_2_3/X
+ sky130_fd_sc_hd__or4_2_3/B sky130_fd_sc_hd__or4_2_3/D VPWR VGND VPWR VGND sky130_fd_sc_hd__or4_2
Xsky130_fd_sc_hd__o32a_2_0 sky130_fd_sc_hd__o32a_2_1/B2 sky130_fd_sc_hd__nor2_2_3/Y
+ sky130_fd_sc_hd__o32a_2_0/A3 sky130_fd_sc_hd__and3_2_0/X sky130_fd_sc_hd__or4_2_0/A
+ sky130_fd_sc_hd__o32a_2_0/X VGND VPWR VPWR VGND sky130_fd_sc_hd__o32a_2
Xsky130_fd_sc_hd__or4b_2_6 sky130_fd_sc_hd__or4_2_4/C sky130_fd_sc_hd__or4_2_4/A sky130_fd_sc_hd__or4_2_7/C
+ sky130_fd_sc_hd__or4_2_4/D sky130_fd_sc_hd__or4_2_4/B VPWR VGND VPWR VGND sky130_fd_sc_hd__or4b_2
Xsky130_fd_sc_hd__xor2_2_14 sky130_fd_sc_hd__xor2_2_14/X sky130_fd_sc_hd__xor2_2_14/B
+ sky130_fd_sc_hd__xor2_2_16/A VPWR VGND VPWR VGND sky130_fd_sc_hd__xor2_2
Xsky130_fd_sc_hd__decap_3_202 VPWR VGND sky130_fd_sc_hd__decap_3_29/VPB VGND sky130_fd_sc_hd__decap_3
Xsky130_fd_sc_hd__and4bb_2_11 sky130_fd_sc_hd__or4_2_4/B sky130_fd_sc_hd__or4_2_4/D
+ sky130_fd_sc_hd__or4_2_4/C sky130_fd_sc_hd__nand4_2_12/D sky130_fd_sc_hd__or4_2_4/A
+ VGND VPWR VPWR VGND sky130_fd_sc_hd__and4bb_2
Xsky130_fd_sc_hd__clkbuf_4_3 sky130_fd_sc_hd__clkbuf_4_3/X sky130_fd_sc_hd__clkbuf_8_3/X
+ VGND VPWR VPWR VGND sky130_fd_sc_hd__clkbuf_4
Xsky130_fd_sc_hd__a21oi_2_7 sky130_fd_sc_hd__and4bb_2_0/X sky130_fd_sc_hd__o22ai_2_0/Y
+ sky130_fd_sc_hd__xor2_2_6/A sky130_fd_sc_hd__xor2_2_5/A VGND VPWR VPWR VGND sky130_fd_sc_hd__a21oi_2
Xsky130_fd_sc_hd__nand2b_2_4 sky130_fd_sc_hd__nand4_2_5/Y sky130_fd_sc_hd__nand2b_2_4/Y
+ sky130_fd_sc_hd__o21a_2_30/A1 VGND VPWR VPWR VGND sky130_fd_sc_hd__nand2b_2
Xsky130_fd_sc_hd__o211a_2_7 sky130_fd_sc_hd__inv_2_5/Y sky130_fd_sc_hd__a31o_2_8/X
+ sky130_fd_sc_hd__mux2_1_5/A1 sky130_fd_sc_hd__and3_2_7/C sky130_fd_sc_hd__o211a_2_7/X
+ VPWR VGND VPWR VGND sky130_fd_sc_hd__o211a_2
Xsky130_fd_sc_hd__and3_2_18 sky130_fd_sc_hd__o31a_2_6/X O[1] sky130_fd_sc_hd__or2_2_11/B
+ sky130_fd_sc_hd__and3_2_25/C VPWR VGND VPWR VGND sky130_fd_sc_hd__and3_2
Xsky130_fd_sc_hd__a21bo_2_1 sky130_fd_sc_hd__a211o_2_2/X sky130_fd_sc_hd__nor2_2_5/Y
+ sky130_fd_sc_hd__a21o_2_3/A2 sky130_fd_sc_hd__or4_2_0/A VGND VPWR VPWR VGND sky130_fd_sc_hd__a21bo_2
Xsky130_fd_sc_hd__decap_3_1 VPWR VGND VPWR VGND sky130_fd_sc_hd__decap_3
Xsky130_fd_sc_hd__o311a_2_1 sky130_fd_sc_hd__o311a_2_1/X sky130_fd_sc_hd__and3_2_7/C
+ sky130_fd_sc_hd__mux2_1_5/A1 sky130_fd_sc_hd__xor2_2_7/A sky130_fd_sc_hd__nand3_2_0/Y
+ sky130_fd_sc_hd__a21o_2_9/X VPWR VGND VPWR VGND sky130_fd_sc_hd__o311a_2
Xsky130_fd_sc_hd__a21oi_2_11 sky130_fd_sc_hd__or3_2_8/A sky130_fd_sc_hd__inv_2_7/A
+ I sky130_fd_sc_hd__nor2_2_30/B VGND VPWR VPWR VGND sky130_fd_sc_hd__a21oi_2
Xsky130_fd_sc_hd__dfrtp_2_20 sky130_fd_sc_hd__and4_2_3/C rst_n sky130_fd_sc_hd__xnor2_2_11/Y
+ sky130_fd_sc_hd__clkbuf_8_3/X VGND VPWR VPWR VGND sky130_fd_sc_hd__dfrtp_2
Xsky130_fd_sc_hd__dfrtp_2_42 sky130_fd_sc_hd__mux2_1_15/A0 rst_n sky130_fd_sc_hd__mux2_1_15/X
+ sky130_fd_sc_hd__clkbuf_8_6/X VGND VPWR VPWR VGND sky130_fd_sc_hd__dfrtp_2
Xsky130_fd_sc_hd__dfrtp_2_31 sky130_fd_sc_hd__mux2_1_19/A1 rst_n sky130_fd_sc_hd__mux2_1_18/X
+ sky130_fd_sc_hd__clkbuf_8_5/X VGND VPWR VPWR VGND sky130_fd_sc_hd__dfrtp_2
Xsky130_fd_sc_hd__dfrtp_2_75 sky130_fd_sc_hd__nand4_2_11/C rst_n sky130_fd_sc_hd__o21a_2_24/X
+ sky130_fd_sc_hd__clkbuf_8_10/X VGND VPWR VPWR VGND sky130_fd_sc_hd__dfrtp_2
Xsky130_fd_sc_hd__dfrtp_2_64 sky130_fd_sc_hd__o21a_2_28/A1 rst_n sky130_fd_sc_hd__dfrtp_2_64/D
+ sky130_fd_sc_hd__clkbuf_8_11/X VGND VPWR VPWR VGND sky130_fd_sc_hd__dfrtp_2
Xsky130_fd_sc_hd__dfrtp_2_53 sky130_fd_sc_hd__nand4_2_5/C rst_n sky130_fd_sc_hd__o21a_2_30/X
+ sky130_fd_sc_hd__clkbuf_8_2/X VGND VPWR sky130_fd_sc_hd__nand4_2_5/VPB VGND sky130_fd_sc_hd__dfrtp_2
Xsky130_fd_sc_hd__inv_2_12 sky130_fd_sc_hd__inv_2_12/A sky130_fd_sc_hd__inv_2_12/Y
+ VPWR VGND VPWR VGND sky130_fd_sc_hd__inv_2
Xsky130_fd_sc_hd__inv_2_23 sky130_fd_sc_hd__inv_2_23/A sky130_fd_sc_hd__inv_2_23/Y
+ VPWR VGND VPWR VGND sky130_fd_sc_hd__inv_2
Xsky130_fd_sc_hd__nand2_2_2 sky130_fd_sc_hd__nand2_2_2/Y sky130_fd_sc_hd__xor2_2_7/A
+ sky130_fd_sc_hd__xor2_2_0/B VGND VPWR VPWR VGND sky130_fd_sc_hd__nand2_2
Xsky130_fd_sc_hd__or4_2_4 sky130_fd_sc_hd__or4_2_4/C sky130_fd_sc_hd__or4_2_4/A sky130_fd_sc_hd__or4_2_4/X
+ sky130_fd_sc_hd__or4_2_4/B sky130_fd_sc_hd__or4_2_4/D VPWR VGND VPWR VGND sky130_fd_sc_hd__or4_2
Xsky130_fd_sc_hd__o32a_2_1 sky130_fd_sc_hd__o32a_2_1/B1 sky130_fd_sc_hd__o32a_2_1/B2
+ sky130_fd_sc_hd__o32a_2_1/A3 sky130_fd_sc_hd__and3_2_0/X sky130_fd_sc_hd__or4_2_0/A
+ sky130_fd_sc_hd__o32a_2_1/X VGND VPWR VPWR VGND sky130_fd_sc_hd__o32a_2
Xsky130_fd_sc_hd__or4b_2_7 sky130_fd_sc_hd__or4_2_4/C sky130_fd_sc_hd__or4_2_4/B sky130_fd_sc_hd__or4_2_6/C
+ sky130_fd_sc_hd__or4_2_4/A sky130_fd_sc_hd__or4_2_4/D VPWR VGND VPWR VGND sky130_fd_sc_hd__or4b_2
Xsky130_fd_sc_hd__xor2_2_15 sky130_fd_sc_hd__xor2_2_15/X sky130_fd_sc_hd__or2_2_9/X
+ sky130_fd_sc_hd__xor2_2_19/B VPWR VGND VPWR VGND sky130_fd_sc_hd__xor2_2
Xsky130_fd_sc_hd__decap_3_203 VPWR VGND sky130_fd_sc_hd__decap_3_61/VPB VGND sky130_fd_sc_hd__decap_3
Xsky130_fd_sc_hd__a21boi_2_0 sky130_fd_sc_hd__inv_2_7/A sky130_fd_sc_hd__nor2_2_40/A
+ I sky130_fd_sc_hd__o21ai_2_3/B1 VPWR VGND sky130_fd_sc_hd__nor2_2_34/VPB VGND sky130_fd_sc_hd__a21boi_2
Xsky130_fd_sc_hd__and4bb_2_12 sky130_fd_sc_hd__or4_2_4/A sky130_fd_sc_hd__or4_2_4/D
+ sky130_fd_sc_hd__or4_2_4/C sky130_fd_sc_hd__nand4_2_13/D sky130_fd_sc_hd__or4_2_4/B
+ VGND VPWR VPWR VGND sky130_fd_sc_hd__and4bb_2
Xsky130_fd_sc_hd__clkbuf_4_4 sky130_fd_sc_hd__clkbuf_4_4/X sky130_fd_sc_hd__clkbuf_8_2/X
+ VGND VPWR VPWR VGND sky130_fd_sc_hd__clkbuf_4
Xsky130_fd_sc_hd__a21oi_2_8 sky130_fd_sc_hd__or2_2_8/B sky130_fd_sc_hd__or2_2_9/A
+ sky130_fd_sc_hd__or3b_2_0/A sky130_fd_sc_hd__and3b_2_0/C VGND VPWR VPWR VGND sky130_fd_sc_hd__a21oi_2
Xsky130_fd_sc_hd__nand2b_2_5 sky130_fd_sc_hd__o21a_2_5/A2 sky130_fd_sc_hd__dfrtp_2_4/D
+ sky130_fd_sc_hd__o21a_2_5/A1 VGND VPWR VPWR VGND sky130_fd_sc_hd__nand2b_2
Xsky130_fd_sc_hd__o211a_2_8 sky130_fd_sc_hd__inv_2_7/A sky130_fd_sc_hd__or2_2_7/X
+ sky130_fd_sc_hd__mux2_1_7/A0 sky130_fd_sc_hd__inv_2_8/A sky130_fd_sc_hd__o211a_2_8/X
+ VPWR VGND VPWR VGND sky130_fd_sc_hd__o211a_2
Xsky130_fd_sc_hd__and3_2_19 sky130_fd_sc_hd__o31a_2_4/X O[6] sky130_fd_sc_hd__or2_2_11/B
+ sky130_fd_sc_hd__and3_2_25/C VPWR VGND VPWR VGND sky130_fd_sc_hd__and3_2
Xsky130_fd_sc_hd__o22a_2_0 sky130_fd_sc_hd__mux2_1_4/S sky130_fd_sc_hd__o22a_2_0/X
+ sky130_fd_sc_hd__or2_2_4/X sky130_fd_sc_hd__or3_2_3/B sky130_fd_sc_hd__nor2_2_4/Y
+ VGND VPWR VPWR VGND sky130_fd_sc_hd__o22a_2
Xsky130_fd_sc_hd__and2b_2_20 sky130_fd_sc_hd__and4_2_1/C sky130_fd_sc_hd__o21a_2_30/A1
+ sky130_fd_sc_hd__nand4_2_5/C VPWR VGND sky130_fd_sc_hd__nand4_2_5/VPB VGND sky130_fd_sc_hd__and2b_2
Xsky130_fd_sc_hd__decap_3_2 VPWR VGND sky130_fd_sc_hd__decap_3_2/VPB VGND sky130_fd_sc_hd__decap_3
Xsky130_fd_sc_hd__a21oi_2_12 sky130_fd_sc_hd__mux2_1_6/X sky130_fd_sc_hd__mux2_1_7/A0
+ sky130_fd_sc_hd__inv_2_8/Y sky130_fd_sc_hd__dfrtp_2_29/D VGND VPWR VPWR VGND sky130_fd_sc_hd__a21oi_2
Xsky130_fd_sc_hd__dfrtp_2_10 sky130_fd_sc_hd__o21a_2_30/A1 rst_n sky130_fd_sc_hd__nand2b_2_4/Y
+ sky130_fd_sc_hd__clkbuf_8_2/X VGND VPWR VPWR VGND sky130_fd_sc_hd__dfrtp_2
Xsky130_fd_sc_hd__dfrtp_2_21 sky130_fd_sc_hd__nor3_2_2/A rst_n sky130_fd_sc_hd__o21a_2_12/X
+ sky130_fd_sc_hd__clkbuf_8_3/X VGND VPWR VPWR VGND sky130_fd_sc_hd__dfrtp_2
Xsky130_fd_sc_hd__dfrtp_2_43 sky130_fd_sc_hd__or4_2_4/B rst_n sky130_fd_sc_hd__dfrtp_2_43/D
+ sky130_fd_sc_hd__clkbuf_8_5/X VGND VPWR VPWR VGND sky130_fd_sc_hd__dfrtp_2
Xsky130_fd_sc_hd__dfrtp_2_32 sky130_fd_sc_hd__mux2_1_9/A1 rst_n sky130_fd_sc_hd__mux2_1_17/X
+ sky130_fd_sc_hd__clkbuf_8_6/X VGND VPWR VPWR VGND sky130_fd_sc_hd__dfrtp_2
Xsky130_fd_sc_hd__dfrtp_2_65 sky130_fd_sc_hd__inv_2_19/A rst_n sky130_fd_sc_hd__o21a_2_22/X
+ sky130_fd_sc_hd__clkbuf_8_9/X VGND VPWR VPWR VGND sky130_fd_sc_hd__dfrtp_2
Xsky130_fd_sc_hd__dfrtp_2_76 sky130_fd_sc_hd__inv_2_17/A rst_n sky130_fd_sc_hd__o21a_2_29/X
+ sky130_fd_sc_hd__dfxtp_2_3/CLK VGND VPWR VPWR VGND sky130_fd_sc_hd__dfrtp_2
Xsky130_fd_sc_hd__dfrtp_2_54 sky130_fd_sc_hd__inv_2_16/A rst_n sky130_fd_sc_hd__o21a_2_17/X
+ sky130_fd_sc_hd__clkbuf_4_9/A VGND VPWR VPWR VGND sky130_fd_sc_hd__dfrtp_2
Xsky130_fd_sc_hd__inv_2_24 sky130_fd_sc_hd__or4b_2_8/X sky130_fd_sc_hd__nor3_2_3/C
+ VPWR VGND VPWR VGND sky130_fd_sc_hd__inv_2
Xsky130_fd_sc_hd__inv_2_13 sky130_fd_sc_hd__or2_2_8/B sky130_fd_sc_hd__inv_2_13/Y
+ VPWR VGND VPWR VGND sky130_fd_sc_hd__inv_2
Xsky130_fd_sc_hd__nand2_2_3 sky130_fd_sc_hd__nand2_2_3/Y sky130_fd_sc_hd__or4_2_0/A
+ sky130_fd_sc_hd__o21a_2_3/A2 VGND VPWR VPWR VGND sky130_fd_sc_hd__nand2_2
Xsky130_fd_sc_hd__or4_2_5 sky130_fd_sc_hd__or4_2_5/C sky130_fd_sc_hd__or4_2_5/A sky130_fd_sc_hd__or4_2_5/X
+ sky130_fd_sc_hd__or4_2_5/B sky130_fd_sc_hd__or4_2_5/D VPWR VGND VPWR VGND sky130_fd_sc_hd__or4_2
Xsky130_fd_sc_hd__and4b_2_0 sky130_fd_sc_hd__or3_2_6/B sky130_fd_sc_hd__or2_2_8/B
+ sky130_fd_sc_hd__or3b_2_0/A sky130_fd_sc_hd__or2_2_9/A sky130_fd_sc_hd__or2_2_9/B
+ VPWR VGND VPWR VGND sky130_fd_sc_hd__and4b_2
Xsky130_fd_sc_hd__nor3_2_0 sky130_fd_sc_hd__or2_2_9/B sky130_fd_sc_hd__nor3_2_0/Y
+ sky130_fd_sc_hd__or3b_2_0/A sky130_fd_sc_hd__or2_2_9/A VGND VPWR VPWR VGND sky130_fd_sc_hd__nor3_2
Xsky130_fd_sc_hd__o32a_2_2 sky130_fd_sc_hd__o32a_2_2/B1 sky130_fd_sc_hd__o32a_2_2/B2
+ sky130_fd_sc_hd__o32a_2_2/A3 sky130_fd_sc_hd__o32a_2_2/A2 sky130_fd_sc_hd__inv_2_12/Y
+ sky130_fd_sc_hd__o32a_2_2/X VGND VPWR VPWR VGND sky130_fd_sc_hd__o32a_2
Xsky130_fd_sc_hd__or4b_2_8 sky130_fd_sc_hd__or4b_2_8/C sky130_fd_sc_hd__or4b_2_8/A
+ sky130_fd_sc_hd__or4b_2_8/X success sky130_fd_sc_hd__a32o_2_3/B1 VPWR VGND VPWR
+ VGND sky130_fd_sc_hd__or4b_2
Xsky130_fd_sc_hd__xor2_2_16 sky130_fd_sc_hd__xor2_2_16/X sky130_fd_sc_hd__or2_2_12/B
+ sky130_fd_sc_hd__xor2_2_16/A VPWR VGND VPWR VGND sky130_fd_sc_hd__xor2_2
Xsky130_fd_sc_hd__a21boi_2_1 sky130_fd_sc_hd__or2_2_11/B sky130_fd_sc_hd__xnor2_2_28/Y
+ sky130_fd_sc_hd__and3_2_25/C sky130_fd_sc_hd__dfxtp_2_1/D VPWR VGND VPWR VGND sky130_fd_sc_hd__a21boi_2
Xsky130_fd_sc_hd__and4bb_2_13 sky130_fd_sc_hd__or4_2_4/A sky130_fd_sc_hd__or4_2_4/C
+ sky130_fd_sc_hd__or4_2_4/D sky130_fd_sc_hd__nand4_2_10/D sky130_fd_sc_hd__or4_2_4/B
+ VGND VPWR VPWR VGND sky130_fd_sc_hd__and4bb_2
Xsky130_fd_sc_hd__clkbuf_4_5 sky130_fd_sc_hd__clkbuf_4_5/X sky130_fd_sc_hd__clkbuf_8_5/X
+ VGND VPWR VPWR VGND sky130_fd_sc_hd__clkbuf_4
Xsky130_fd_sc_hd__a21oi_2_9 sky130_fd_sc_hd__or2_2_8/B sky130_fd_sc_hd__or2_2_9/A
+ sky130_fd_sc_hd__or3b_2_0/A sky130_fd_sc_hd__or3_2_6/A VGND VPWR VPWR VGND sky130_fd_sc_hd__a21oi_2
Xsky130_fd_sc_hd__nand2b_2_6 sky130_fd_sc_hd__xor2_2_4/X sky130_fd_sc_hd__and3_2_4/A
+ sky130_fd_sc_hd__xnor2_2_4/A VGND VPWR VPWR VGND sky130_fd_sc_hd__nand2b_2
Xsky130_fd_sc_hd__o211a_2_9 sky130_fd_sc_hd__o21ai_2_5/Y sky130_fd_sc_hd__o21a_2_15/A2
+ sky130_fd_sc_hd__or2_2_8/X sky130_fd_sc_hd__or2_2_9/A sky130_fd_sc_hd__o211a_2_9/X
+ VPWR VGND sky130_fd_sc_hd__or2_2_8/VPB VGND sky130_fd_sc_hd__o211a_2
Xsky130_fd_sc_hd__a221o_2_0 sky130_fd_sc_hd__a221o_2_0/X sky130_fd_sc_hd__or2_2_5/X
+ sky130_fd_sc_hd__or4_2_0/A sky130_fd_sc_hd__a21oi_2_2/Y sky130_fd_sc_hd__o22ai_2_1/Y
+ VGND VPWR sky130_fd_sc_hd__or3_2_7/A VPWR VGND sky130_fd_sc_hd__a221o_2
Xsky130_fd_sc_hd__o22a_2_1 sky130_fd_sc_hd__or2_2_9/B sky130_fd_sc_hd__or3_2_16/A
+ sky130_fd_sc_hd__or3_2_6/A sky130_fd_sc_hd__or2_2_9/A sky130_fd_sc_hd__or3_2_6/B
+ VGND VPWR VPWR VGND sky130_fd_sc_hd__o22a_2
Xsky130_fd_sc_hd__o21a_2_30 sky130_fd_sc_hd__o21a_2_30/A1 sky130_fd_sc_hd__a31o_2_25/X
+ sky130_fd_sc_hd__nand4_2_5/Y sky130_fd_sc_hd__o21a_2_30/X VGND VPWR VPWR VGND sky130_fd_sc_hd__o21a_2
Xsky130_fd_sc_hd__and2b_2_10 sky130_fd_sc_hd__dfrtp_2_25/D sky130_fd_sc_hd__a21o_2_10/X
+ sky130_fd_sc_hd__and3_2_11/X VPWR VGND VPWR VGND sky130_fd_sc_hd__and2b_2
Xsky130_fd_sc_hd__and2b_2_21 sky130_fd_sc_hd__and3_2_5/C sky130_fd_sc_hd__o21a_2_18/A1
+ sky130_fd_sc_hd__nand4_2_6/C VPWR VGND VPWR VGND sky130_fd_sc_hd__and2b_2
Xsky130_fd_sc_hd__decap_3_3 VPWR VGND VPWR VGND sky130_fd_sc_hd__decap_3
Xsky130_fd_sc_hd__a21oi_2_13 sky130_fd_sc_hd__or4_2_4/B sky130_fd_sc_hd__inv_2_7/A
+ sky130_fd_sc_hd__or4_2_4/A sky130_fd_sc_hd__a21oi_2_13/Y VGND VPWR VPWR VGND sky130_fd_sc_hd__a21oi_2
Xsky130_fd_sc_hd__dfrtp_2_22 sky130_fd_sc_hd__or3_2_8/C rst_n sky130_fd_sc_hd__xor2_2_10/X
+ sky130_fd_sc_hd__dfrtp_2_8/CLK VGND VPWR VPWR VGND sky130_fd_sc_hd__dfrtp_2
Xsky130_fd_sc_hd__dfrtp_2_11 sky130_fd_sc_hd__and2b_2_3/B rst_n sky130_fd_sc_hd__nand2b_2_2/Y
+ sky130_fd_sc_hd__clkbuf_8_1/X VGND VPWR VPWR VGND sky130_fd_sc_hd__dfrtp_2
Xsky130_fd_sc_hd__dfrtp_2_33 sky130_fd_sc_hd__mux2_1_12/A1 rst_n sky130_fd_sc_hd__mux2_1_10/X
+ sky130_fd_sc_hd__clkbuf_8_2/X VGND VPWR VPWR VGND sky130_fd_sc_hd__dfrtp_2
Xsky130_fd_sc_hd__dfrtp_2_66 sky130_fd_sc_hd__o21a_2_21/A1 rst_n sky130_fd_sc_hd__dfrtp_2_66/D
+ sky130_fd_sc_hd__clkbuf_8_10/X VGND VPWR VPWR VGND sky130_fd_sc_hd__dfrtp_2
Xsky130_fd_sc_hd__dfrtp_2_77 sky130_fd_sc_hd__or4_2_7/A rst_n sky130_fd_sc_hd__a21o_2_14/X
+ sky130_fd_sc_hd__clkbuf_8_9/X VGND VPWR VPWR VGND sky130_fd_sc_hd__dfrtp_2
Xsky130_fd_sc_hd__dfrtp_2_55 sky130_fd_sc_hd__nand4_2_6/C rst_n sky130_fd_sc_hd__o21a_2_18/X
+ sky130_fd_sc_hd__clkbuf_8_8/X VGND VPWR VPWR VGND sky130_fd_sc_hd__dfrtp_2
Xsky130_fd_sc_hd__dfrtp_2_44 sky130_fd_sc_hd__or4_2_4/A rst_n sky130_fd_sc_hd__nor2_2_31/Y
+ sky130_fd_sc_hd__clkbuf_8_5/X VGND VPWR VPWR VGND sky130_fd_sc_hd__dfrtp_2
Xsky130_fd_sc_hd__inv_2_14 sky130_fd_sc_hd__or2_2_8/B sky130_fd_sc_hd__inv_2_14/Y
+ VPWR VGND sky130_fd_sc_hd__o31a_2_2/VPB VGND sky130_fd_sc_hd__inv_2
Xsky130_fd_sc_hd__nand2_2_4 sky130_fd_sc_hd__nor2_2_0/B sky130_fd_sc_hd__or4_2_4/A
+ sky130_fd_sc_hd__xor2_2_7/A VGND VPWR VPWR VGND sky130_fd_sc_hd__nand2_2
Xsky130_fd_sc_hd__or4_2_6 sky130_fd_sc_hd__or4_2_6/C sky130_fd_sc_hd__or4_2_6/A sky130_fd_sc_hd__or4_2_6/X
+ sky130_fd_sc_hd__or4_2_6/B sky130_fd_sc_hd__or4_2_6/D VPWR VGND VPWR VGND sky130_fd_sc_hd__or4_2
Xsky130_fd_sc_hd__and4b_2_1 sky130_fd_sc_hd__nand4_2_5/D sky130_fd_sc_hd__or4b_2_2/C
+ sky130_fd_sc_hd__or4b_2_3/A sky130_fd_sc_hd__or4b_2_3/B sky130_fd_sc_hd__or4b_2_3/C
+ VPWR VGND VPWR VGND sky130_fd_sc_hd__and4b_2
Xsky130_fd_sc_hd__nor3_2_1 sky130_fd_sc_hd__nor3_2_1/C sky130_fd_sc_hd__nor3_2_1/Y
+ sky130_fd_sc_hd__or2_2_9/B sky130_fd_sc_hd__nor3_2_1/B VGND VPWR VPWR VGND sky130_fd_sc_hd__nor3_2
Xsky130_fd_sc_hd__o32a_2_3 sky130_fd_sc_hd__or2_2_10/X sky130_fd_sc_hd__or2_2_12/A
+ sky130_fd_sc_hd__o32a_2_3/A3 sky130_fd_sc_hd__o32a_2_3/A2 sky130_fd_sc_hd__o32a_2_3/A1
+ sky130_fd_sc_hd__o32a_2_3/X VGND VPWR VPWR VGND sky130_fd_sc_hd__o32a_2
Xsky130_fd_sc_hd__xor2_2_17 sky130_fd_sc_hd__xor2_2_17/X sky130_fd_sc_hd__xor2_2_17/B
+ sky130_fd_sc_hd__xor2_2_19/A VPWR VGND VPWR VGND sky130_fd_sc_hd__xor2_2
Xsky130_fd_sc_hd__a21boi_2_2 sky130_fd_sc_hd__or2_2_11/B sky130_fd_sc_hd__nand3_2_1/Y
+ sky130_fd_sc_hd__inv_2_21/Y sky130_fd_sc_hd__dfxtp_2_0/D VPWR VGND VPWR VGND sky130_fd_sc_hd__a21boi_2
Xsky130_fd_sc_hd__clkbuf_4_6 sky130_fd_sc_hd__clkbuf_4_6/X sky130_fd_sc_hd__clkbuf_8_6/X
+ VGND VPWR VPWR VGND sky130_fd_sc_hd__clkbuf_4
Xsky130_fd_sc_hd__and3_2_0 sky130_fd_sc_hd__or3_2_0/B sky130_fd_sc_hd__and3_2_0/X
+ sky130_fd_sc_hd__or2_2_4/A sky130_fd_sc_hd__and3_2_0/C VPWR VGND VPWR VGND sky130_fd_sc_hd__and3_2
Xsky130_fd_sc_hd__nand2b_2_7 sky130_fd_sc_hd__or3b_2_0/A sky130_fd_sc_hd__a21o_2_6/A2
+ sky130_fd_sc_hd__or2_2_9/B VGND VPWR sky130_fd_sc_hd__o31a_2_0/VPB VGND sky130_fd_sc_hd__nand2b_2
Xsky130_fd_sc_hd__o22a_2_2 sky130_fd_sc_hd__and2_2_8/A sky130_fd_sc_hd__o22a_2_2/X
+ sky130_fd_sc_hd__and2_2_8/B sky130_fd_sc_hd__or2_2_8/B sky130_fd_sc_hd__nor3_2_1/B
+ VGND VPWR sky130_fd_sc_hd__o22a_2_2/VPB VGND sky130_fd_sc_hd__o22a_2
Xsky130_fd_sc_hd__a221o_2_1 sky130_fd_sc_hd__a221o_2_1/X sky130_fd_sc_hd__conb_1_2/HI
+ sky130_fd_sc_hd__or4bb_2_0/X sky130_fd_sc_hd__mux2_1_12/A0 sky130_fd_sc_hd__mux2_1_12/A1
+ VGND VPWR sky130_fd_sc_hd__a22o_2_2/X VPWR VGND sky130_fd_sc_hd__a221o_2
Xsky130_fd_sc_hd__o21a_2_20 sky130_fd_sc_hd__inv_2_18/A sky130_fd_sc_hd__or4_2_7/X
+ sky130_fd_sc_hd__nor2_2_43/Y sky130_fd_sc_hd__o21a_2_20/X VGND VPWR VPWR VGND sky130_fd_sc_hd__o21a_2
Xsky130_fd_sc_hd__and2_2_10 sky130_fd_sc_hd__or4_2_5/A sky130_fd_sc_hd__and3_2_5/B
+ sky130_fd_sc_hd__or4_2_5/B VPWR VGND VPWR VGND sky130_fd_sc_hd__and2_2
Xsky130_fd_sc_hd__and2b_2_11 sky130_fd_sc_hd__inv_2_7/A enable sky130_fd_sc_hd__or2_2_11/A
+ VPWR VGND sky130_fd_sc_hd__diode_2_1/VPB VGND sky130_fd_sc_hd__and2b_2
Xsky130_fd_sc_hd__and2b_2_22 sky130_fd_sc_hd__and3_2_5/A sky130_fd_sc_hd__o21a_2_16/A1
+ sky130_fd_sc_hd__nand4_2_4/C VPWR VGND VPWR VGND sky130_fd_sc_hd__and2b_2
Xsky130_fd_sc_hd__a211o_2_0 sky130_fd_sc_hd__a211o_2_0/X sky130_fd_sc_hd__a32o_2_1/X
+ sky130_fd_sc_hd__or2_2_5/A sky130_fd_sc_hd__o221a_2_0/X sky130_fd_sc_hd__or3_2_7/A
+ VGND VPWR VPWR VGND sky130_fd_sc_hd__a211o_2
Xsky130_fd_sc_hd__decap_3_4 VPWR VGND VPWR VGND sky130_fd_sc_hd__decap_3
Xsky130_fd_sc_hd__dfxtp_2_0 sky130_fd_sc_hd__or2_2_8/B sky130_fd_sc_hd__dfxtp_2_3/CLK
+ sky130_fd_sc_hd__dfxtp_2_0/D VPWR VGND VPWR VGND sky130_fd_sc_hd__dfxtp_2
Xsky130_fd_sc_hd__a21oi_2_14 sky130_fd_sc_hd__or2_2_9/B sky130_fd_sc_hd__or2_2_8/B
+ sky130_fd_sc_hd__or3b_2_0/A sky130_fd_sc_hd__o221a_2_2/B2 VGND VPWR VPWR VGND sky130_fd_sc_hd__a21oi_2
Xsky130_fd_sc_hd__dfrtp_2_23 sky130_fd_sc_hd__or3_2_8/A rst_n sky130_fd_sc_hd__nor2_2_30/Y
+ sky130_fd_sc_hd__dfrtp_2_8/CLK VGND VPWR VPWR VGND sky130_fd_sc_hd__dfrtp_2
Xsky130_fd_sc_hd__dfrtp_2_12 sky130_fd_sc_hd__o21a_2_8/A1 rst_n sky130_fd_sc_hd__nand2b_2_3/Y
+ sky130_fd_sc_hd__clkbuf_8_1/X VGND VPWR VPWR VGND sky130_fd_sc_hd__dfrtp_2
Xsky130_fd_sc_hd__dfrtp_2_34 sky130_fd_sc_hd__mux2_1_8/A0 rst_n sky130_fd_sc_hd__mux2_1_8/X
+ sky130_fd_sc_hd__clkbuf_8_2/X VGND VPWR VPWR VGND sky130_fd_sc_hd__dfrtp_2
Xsky130_fd_sc_hd__dfrtp_2_67 sky130_fd_sc_hd__o21a_2_24/A1 rst_n sky130_fd_sc_hd__dfrtp_2_67/D
+ sky130_fd_sc_hd__clkbuf_8_11/X VGND VPWR VPWR VGND sky130_fd_sc_hd__dfrtp_2
Xsky130_fd_sc_hd__dfrtp_2_56 sky130_fd_sc_hd__nand4_2_4/C rst_n sky130_fd_sc_hd__o21a_2_16/X
+ sky130_fd_sc_hd__clkbuf_4_9/A VGND VPWR VPWR VGND sky130_fd_sc_hd__dfrtp_2
Xsky130_fd_sc_hd__dfrtp_2_45 sky130_fd_sc_hd__or4_2_4/D rst_n sky130_fd_sc_hd__dfrtp_2_45/D
+ sky130_fd_sc_hd__clkbuf_8_5/X VGND VPWR VPWR VGND sky130_fd_sc_hd__dfrtp_2
Xsky130_fd_sc_hd__dfrtp_2_78 sky130_fd_sc_hd__nand4_2_10/C rst_n sky130_fd_sc_hd__o21a_2_28/X
+ sky130_fd_sc_hd__clkbuf_8_10/X VGND VPWR VPWR VGND sky130_fd_sc_hd__dfrtp_2
Xsky130_fd_sc_hd__inv_2_15 sky130_fd_sc_hd__or3b_2_0/A sky130_fd_sc_hd__inv_2_15/Y
+ VPWR VGND sky130_fd_sc_hd__inv_2_15/VPB VGND sky130_fd_sc_hd__inv_2
Xsky130_fd_sc_hd__nand2_2_5 sky130_fd_sc_hd__nand2_2_5/Y sky130_fd_sc_hd__or3_2_0/B
+ sky130_fd_sc_hd__or3_2_2/B VGND VPWR VPWR VGND sky130_fd_sc_hd__nand2_2
Xsky130_fd_sc_hd__or4_2_7 sky130_fd_sc_hd__or4_2_7/C sky130_fd_sc_hd__or4_2_7/A sky130_fd_sc_hd__or4_2_7/X
+ sky130_fd_sc_hd__or4_2_7/B sky130_fd_sc_hd__or4_2_7/D VPWR VGND VPWR VGND sky130_fd_sc_hd__or4_2
Xsky130_fd_sc_hd__and4b_2_2 sky130_fd_sc_hd__and4b_2_2/X sky130_fd_sc_hd__or4_2_4/D
+ sky130_fd_sc_hd__or4_2_4/B sky130_fd_sc_hd__or4_2_4/A sky130_fd_sc_hd__or4_2_4/C
+ VPWR VGND VPWR VGND sky130_fd_sc_hd__and4b_2
Xsky130_fd_sc_hd__buf_2_0 VPWR VGND sky130_fd_sc_hd__buf_2_0/X sky130_fd_sc_hd__or4_2_4/X
+ VPWR VGND sky130_fd_sc_hd__buf_2
Xsky130_fd_sc_hd__inv_2_0 sky130_fd_sc_hd__or3_2_3/C sky130_fd_sc_hd__inv_2_0/Y VPWR
+ VGND VPWR VGND sky130_fd_sc_hd__inv_2
Xsky130_fd_sc_hd__nor3_2_2 sky130_fd_sc_hd__or3_2_8/X sky130_fd_sc_hd__nor3_2_2/Y
+ sky130_fd_sc_hd__nor3_2_2/A sky130_fd_sc_hd__nor3_2_2/B VGND VPWR VPWR VGND sky130_fd_sc_hd__nor3_2
Xsky130_fd_sc_hd__xor2_2_18 sky130_fd_sc_hd__xor2_2_18/X sky130_fd_sc_hd__o32a_2_2/X
+ sky130_fd_sc_hd__xor2_2_19/A VPWR VGND VPWR VGND sky130_fd_sc_hd__xor2_2
Xsky130_fd_sc_hd__a21boi_2_3 sky130_fd_sc_hd__or2_2_11/B sky130_fd_sc_hd__and3_2_25/C
+ sky130_fd_sc_hd__or3b_2_0/A sky130_fd_sc_hd__dfxtp_2_2/D VPWR VGND sky130_fd_sc_hd__and2_2_16/VPB
+ VGND sky130_fd_sc_hd__a21boi_2
Xsky130_fd_sc_hd__clkbuf_4_7 sky130_fd_sc_hd__clkbuf_4_7/X sky130_fd_sc_hd__clkbuf_8_7/X
+ VGND VPWR VPWR VGND sky130_fd_sc_hd__clkbuf_4
Xsky130_fd_sc_hd__and3_2_1 sky130_fd_sc_hd__inv_2_4/Y sky130_fd_sc_hd__and3_2_1/X
+ sky130_fd_sc_hd__or2_2_4/A sky130_fd_sc_hd__and3_2_1/C VPWR VGND VPWR VGND sky130_fd_sc_hd__and3_2
Xsky130_fd_sc_hd__nand2b_2_8 sky130_fd_sc_hd__or2_2_9/B sky130_fd_sc_hd__nand2b_2_8/Y
+ sky130_fd_sc_hd__or2_2_8/B VGND VPWR VPWR VGND sky130_fd_sc_hd__nand2b_2
Xsky130_fd_sc_hd__o22a_2_3 sky130_fd_sc_hd__or2_2_10/X sky130_fd_sc_hd__o22a_2_3/X
+ sky130_fd_sc_hd__o22a_2_3/B1 sky130_fd_sc_hd__xor2_2_19/A sky130_fd_sc_hd__o22a_2_3/B2
+ VGND VPWR VPWR VGND sky130_fd_sc_hd__o22a_2
Xsky130_fd_sc_hd__a221o_2_2 sky130_fd_sc_hd__a221o_2_2/X sky130_fd_sc_hd__xor2_2_19/B
+ sky130_fd_sc_hd__inv_2_7/A sky130_fd_sc_hd__nor2_2_39/Y sky130_fd_sc_hd__xor2_2_16/A
+ VGND VPWR sky130_fd_sc_hd__nor2_2_46/Y VPWR VGND sky130_fd_sc_hd__a221o_2
Xsky130_fd_sc_hd__o21a_2_21 sky130_fd_sc_hd__o21a_2_21/A1 sky130_fd_sc_hd__a31o_2_24/X
+ sky130_fd_sc_hd__nand4_2_9/Y sky130_fd_sc_hd__o21a_2_21/X VGND VPWR VPWR VGND sky130_fd_sc_hd__o21a_2
Xsky130_fd_sc_hd__o21a_2_10 sky130_fd_sc_hd__and2b_2_3/B sky130_fd_sc_hd__a31o_2_3/X
+ sky130_fd_sc_hd__nand4_2_1/Y sky130_fd_sc_hd__o21a_2_10/X VGND VPWR VPWR VGND sky130_fd_sc_hd__o21a_2
Xsky130_fd_sc_hd__and2_2_11 sky130_fd_sc_hd__or4_2_9/A sky130_fd_sc_hd__and4_2_6/A
+ sky130_fd_sc_hd__or4_2_9/B VPWR VGND VPWR VGND sky130_fd_sc_hd__and2_2
Xsky130_fd_sc_hd__and2b_2_23 sky130_fd_sc_hd__and4_2_6/B sky130_fd_sc_hd__o21a_2_19/A1
+ sky130_fd_sc_hd__nand4_2_7/C VPWR VGND VPWR VGND sky130_fd_sc_hd__and2b_2
Xsky130_fd_sc_hd__and2b_2_12 sky130_fd_sc_hd__and3_2_17/C sky130_fd_sc_hd__or2_2_9/A
+ sky130_fd_sc_hd__or2_2_9/B VPWR VGND VPWR VGND sky130_fd_sc_hd__and2b_2
Xsky130_fd_sc_hd__a211o_2_1 sky130_fd_sc_hd__a211o_2_1/X sky130_fd_sc_hd__or2_2_4/B
+ sky130_fd_sc_hd__or4_2_0/A sky130_fd_sc_hd__mux2_1_4/X sky130_fd_sc_hd__or4_2_0/B
+ VGND VPWR VPWR VGND sky130_fd_sc_hd__a211o_2
Xsky130_fd_sc_hd__decap_3_5 VPWR VGND sky130_fd_sc_hd__decap_3_5/VPB VGND sky130_fd_sc_hd__decap_3
Xsky130_fd_sc_hd__dfxtp_2_1 sky130_fd_sc_hd__or2_2_9/A sky130_fd_sc_hd__dfxtp_2_2/CLK
+ sky130_fd_sc_hd__dfxtp_2_1/D VPWR VGND VPWR VGND sky130_fd_sc_hd__dfxtp_2
Xsky130_fd_sc_hd__a21oi_2_15 sky130_fd_sc_hd__mux2_1_20/X sky130_fd_sc_hd__nor2_2_32/B
+ sky130_fd_sc_hd__or2_2_8/X sky130_fd_sc_hd__a22o_2_21/B2 VGND VPWR VPWR VGND sky130_fd_sc_hd__a21oi_2
Xsky130_fd_sc_hd__dfrtp_2_24 sky130_fd_sc_hd__and4_2_3/A rst_n sky130_fd_sc_hd__a32o_2_2/X
+ sky130_fd_sc_hd__dfrtp_2_8/CLK VGND VPWR VPWR VGND sky130_fd_sc_hd__dfrtp_2
Xsky130_fd_sc_hd__dfrtp_2_13 sky130_fd_sc_hd__or4_2_2/A rst_n sky130_fd_sc_hd__a21o_2_1/X
+ sky130_fd_sc_hd__clkbuf_8_0/X VGND VPWR VPWR VGND sky130_fd_sc_hd__dfrtp_2
Xsky130_fd_sc_hd__dfrtp_2_68 sky130_fd_sc_hd__o21a_2_25/A1 rst_n sky130_fd_sc_hd__dfrtp_2_68/D
+ sky130_fd_sc_hd__clkbuf_8_10/X VGND VPWR VPWR VGND sky130_fd_sc_hd__dfrtp_2
Xsky130_fd_sc_hd__dfrtp_2_57 sky130_fd_sc_hd__o21a_2_19/A1 rst_n sky130_fd_sc_hd__dfrtp_2_57/D
+ sky130_fd_sc_hd__clkbuf_8_8/X VGND VPWR sky130_fd_sc_hd__dfrtp_2_57/VPB VGND sky130_fd_sc_hd__dfrtp_2
Xsky130_fd_sc_hd__dfrtp_2_35 sky130_fd_sc_hd__mux2_1_16/A0 rst_n sky130_fd_sc_hd__mux2_1_16/X
+ sky130_fd_sc_hd__clkbuf_8_2/X VGND VPWR VPWR VGND sky130_fd_sc_hd__dfrtp_2
Xsky130_fd_sc_hd__dfrtp_2_46 sky130_fd_sc_hd__or4_2_4/C rst_n sky130_fd_sc_hd__xor2_2_11/X
+ sky130_fd_sc_hd__clkbuf_8_5/X VGND VPWR VPWR VGND sky130_fd_sc_hd__dfrtp_2
Xsky130_fd_sc_hd__dfrtp_2_79 sky130_fd_sc_hd__or4_2_8/A rst_n sky130_fd_sc_hd__a21o_2_15/X
+ sky130_fd_sc_hd__clkbuf_8_9/X VGND VPWR VPWR VGND sky130_fd_sc_hd__dfrtp_2
Xsky130_fd_sc_hd__inv_2_16 sky130_fd_sc_hd__inv_2_16/A sky130_fd_sc_hd__or4_2_5/B
+ VPWR VGND VPWR VGND sky130_fd_sc_hd__inv_2
Xsky130_fd_sc_hd__nand2_2_6 sky130_fd_sc_hd__nor2_2_5/A sky130_fd_sc_hd__xor2_2_3/A
+ sky130_fd_sc_hd__or3_2_3/A VGND VPWR VPWR VGND sky130_fd_sc_hd__nand2_2
Xsky130_fd_sc_hd__or4_2_8 sky130_fd_sc_hd__or4_2_8/C sky130_fd_sc_hd__or4_2_8/A sky130_fd_sc_hd__or4_2_8/X
+ sky130_fd_sc_hd__or4_2_8/B sky130_fd_sc_hd__or4_2_8/D VPWR VGND VPWR VGND sky130_fd_sc_hd__or4_2
Xsky130_fd_sc_hd__and4b_2_3 sky130_fd_sc_hd__and4b_2_3/X sky130_fd_sc_hd__or2_2_11/B
+ sky130_fd_sc_hd__and4b_2_3/D sky130_fd_sc_hd__and3_2_6/X sky130_fd_sc_hd__or2_2_11/A
+ VPWR VGND VPWR VGND sky130_fd_sc_hd__and4b_2
Xsky130_fd_sc_hd__nor3_2_3 sky130_fd_sc_hd__nor3_2_3/C sky130_fd_sc_hd__nor3_2_3/Y
+ sky130_fd_sc_hd__nor3_2_3/A sky130_fd_sc_hd__nor3_2_3/B VGND VPWR VPWR VGND sky130_fd_sc_hd__nor3_2
Xsky130_fd_sc_hd__inv_2_1 sky130_fd_sc_hd__inv_2_1/A sky130_fd_sc_hd__or4_2_1/B VPWR
+ VGND VPWR VGND sky130_fd_sc_hd__inv_2
Xsky130_fd_sc_hd__xor2_2_19 sky130_fd_sc_hd__xor2_2_19/X sky130_fd_sc_hd__xor2_2_19/B
+ sky130_fd_sc_hd__xor2_2_19/A VPWR VGND VPWR VGND sky130_fd_sc_hd__xor2_2
Xsky130_fd_sc_hd__clkbuf_4_8 sky130_fd_sc_hd__clkbuf_4_8/X sky130_fd_sc_hd__clkbuf_8_8/X
+ VGND VPWR VPWR VGND sky130_fd_sc_hd__clkbuf_4
Xsky130_fd_sc_hd__or3b_2_0 sky130_fd_sc_hd__or3b_2_0/A sky130_fd_sc_hd__or2_2_9/B
+ sky130_fd_sc_hd__or2_2_9/A sky130_fd_sc_hd__or3b_2_0/X VPWR VGND VPWR VGND sky130_fd_sc_hd__or3b_2
Xsky130_fd_sc_hd__xor2_2_0 sky130_fd_sc_hd__xor2_2_0/X sky130_fd_sc_hd__xor2_2_0/B
+ sky130_fd_sc_hd__xor2_2_7/A VPWR VGND VPWR VGND sky130_fd_sc_hd__xor2_2
Xsky130_fd_sc_hd__and3_2_2 sky130_fd_sc_hd__and3_2_2/B sky130_fd_sc_hd__or3_2_5/C
+ sky130_fd_sc_hd__and3_2_2/A sky130_fd_sc_hd__and3_2_2/C VPWR VGND VPWR VGND sky130_fd_sc_hd__and3_2
Xsky130_fd_sc_hd__nand2b_2_9 sky130_fd_sc_hd__or2_2_8/B sky130_fd_sc_hd__o32ai_2_0/B1
+ sky130_fd_sc_hd__or2_2_9/B VGND VPWR VPWR VGND sky130_fd_sc_hd__nand2b_2
Xsky130_fd_sc_hd__a221o_2_3 sky130_fd_sc_hd__o22a_2_3/B2 sky130_fd_sc_hd__nor2_2_34/Y
+ sky130_fd_sc_hd__inv_2_7/A sky130_fd_sc_hd__nor3b_2_0/B sky130_fd_sc_hd__or2_2_12/A
+ VGND VPWR sky130_fd_sc_hd__nor2_2_39/Y VPWR VGND sky130_fd_sc_hd__a221o_2
Xsky130_fd_sc_hd__o21a_2_22 sky130_fd_sc_hd__inv_2_19/A sky130_fd_sc_hd__or4_2_8/X
+ sky130_fd_sc_hd__nor2_2_44/Y sky130_fd_sc_hd__o21a_2_22/X VGND VPWR VPWR VGND sky130_fd_sc_hd__o21a_2
Xsky130_fd_sc_hd__o21a_2_11 sky130_fd_sc_hd__or3_2_8/B sky130_fd_sc_hd__xnor2_2_11/B
+ sky130_fd_sc_hd__and3_2_11/X sky130_fd_sc_hd__o21a_2_11/X VGND VPWR VPWR VGND sky130_fd_sc_hd__o21a_2
Xsky130_fd_sc_hd__and2_2_12 sky130_fd_sc_hd__or4_2_7/A sky130_fd_sc_hd__and4_2_6/D
+ sky130_fd_sc_hd__or4_2_7/B VPWR VGND VPWR VGND sky130_fd_sc_hd__and2_2
Xsky130_fd_sc_hd__and2b_2_13 sky130_fd_sc_hd__nor2_2_32/B sky130_fd_sc_hd__or3b_2_0/A
+ sky130_fd_sc_hd__or2_2_9/A VPWR VGND VPWR VGND sky130_fd_sc_hd__and2b_2
Xsky130_fd_sc_hd__and2b_2_24 sky130_fd_sc_hd__and4_2_6/C sky130_fd_sc_hd__o21a_2_23/A1
+ sky130_fd_sc_hd__nand4_2_8/C VPWR VGND VPWR VGND sky130_fd_sc_hd__and2b_2
Xsky130_fd_sc_hd__a211o_2_2 sky130_fd_sc_hd__a211o_2_2/X sky130_fd_sc_hd__nand2_2_9/Y
+ sky130_fd_sc_hd__or2_2_4/A sky130_fd_sc_hd__or4_2_0/D sky130_fd_sc_hd__or4_2_0/A
+ VGND VPWR VPWR VGND sky130_fd_sc_hd__a211o_2
Xsky130_fd_sc_hd__decap_3_6 VPWR VGND VPWR VGND sky130_fd_sc_hd__decap_3
Xsky130_fd_sc_hd__dfxtp_2_2 sky130_fd_sc_hd__or3b_2_0/A sky130_fd_sc_hd__dfxtp_2_2/CLK
+ sky130_fd_sc_hd__dfxtp_2_2/D VPWR VGND VPWR VGND sky130_fd_sc_hd__dfxtp_2
Xsky130_fd_sc_hd__a21oi_2_16 sky130_fd_sc_hd__or3_2_9/A sky130_fd_sc_hd__o31a_2_1/B1
+ sky130_fd_sc_hd__inv_2_12/A sky130_fd_sc_hd__xnor2_2_14/B VGND VPWR VPWR VGND sky130_fd_sc_hd__a21oi_2
Xsky130_fd_sc_hd__dfrtp_2_25 sky130_fd_sc_hd__and4_2_3/B rst_n sky130_fd_sc_hd__dfrtp_2_25/D
+ sky130_fd_sc_hd__clkbuf_8_3/X VGND VPWR VPWR VGND sky130_fd_sc_hd__dfrtp_2
Xsky130_fd_sc_hd__dfrtp_2_14 sky130_fd_sc_hd__o21a_2_4/A1 rst_n sky130_fd_sc_hd__nand2b_2_1/Y
+ sky130_fd_sc_hd__clkbuf_8_0/X VGND VPWR VPWR VGND sky130_fd_sc_hd__dfrtp_2
Xsky130_fd_sc_hd__dfrtp_2_47 sky130_fd_sc_hd__or2_2_11/A rst_n sky130_fd_sc_hd__a31o_2_13/X
+ sky130_fd_sc_hd__clkbuf_8_8/X VGND VPWR VPWR VGND sky130_fd_sc_hd__dfrtp_2
Xsky130_fd_sc_hd__dfrtp_2_58 sky130_fd_sc_hd__o21a_2_18/A1 rst_n sky130_fd_sc_hd__dfrtp_2_58/D
+ sky130_fd_sc_hd__clkbuf_4_9/A VGND VPWR VPWR VGND sky130_fd_sc_hd__dfrtp_2
Xsky130_fd_sc_hd__dfrtp_2_36 sky130_fd_sc_hd__mux2_1_12/A0 rst_n sky130_fd_sc_hd__mux2_1_12/X
+ sky130_fd_sc_hd__clkbuf_8_6/X VGND VPWR VPWR VGND sky130_fd_sc_hd__dfrtp_2
Xsky130_fd_sc_hd__dfrtp_2_69 sky130_fd_sc_hd__or4_2_6/A rst_n sky130_fd_sc_hd__a21o_2_16/X
+ sky130_fd_sc_hd__clkbuf_8_10/X VGND VPWR VPWR VGND sky130_fd_sc_hd__dfrtp_2
Xsky130_fd_sc_hd__o21bai_2_0 sky130_fd_sc_hd__xnor2_2_6/A sky130_fd_sc_hd__o21bai_2_0/Y
+ sky130_fd_sc_hd__o32ai_2_0/B1 sky130_fd_sc_hd__nor3_2_1/B VGND VPWR VPWR VGND sky130_fd_sc_hd__o21bai_2
Xsky130_fd_sc_hd__inv_2_17 sky130_fd_sc_hd__inv_2_17/A sky130_fd_sc_hd__or4_2_9/B
+ VPWR VGND VPWR VGND sky130_fd_sc_hd__inv_2
Xsky130_fd_sc_hd__nand2_2_7 sky130_fd_sc_hd__nor2_2_9/B sky130_fd_sc_hd__nor2_2_8/A
+ sky130_fd_sc_hd__nor2_2_0/B VGND VPWR VPWR VGND sky130_fd_sc_hd__nand2_2
Xsky130_fd_sc_hd__or4_2_9 sky130_fd_sc_hd__or4_2_9/C sky130_fd_sc_hd__or4_2_9/A sky130_fd_sc_hd__or4_2_9/X
+ sky130_fd_sc_hd__or4_2_9/B sky130_fd_sc_hd__or4_2_9/D VPWR VGND VPWR VGND sky130_fd_sc_hd__or4_2
Xsky130_fd_sc_hd__inv_2_2 sky130_fd_sc_hd__inv_2_2/A sky130_fd_sc_hd__or4_2_2/B VPWR
+ VGND VPWR VGND sky130_fd_sc_hd__inv_2
Xsky130_fd_sc_hd__a41oi_2_0 sky130_fd_sc_hd__inv_2_7/A sky130_fd_sc_hd__or4_2_4/C
+ sky130_fd_sc_hd__or4_2_4/A sky130_fd_sc_hd__or4_2_4/D sky130_fd_sc_hd__or4_2_4/B
+ sky130_fd_sc_hd__a41oi_2_0/Y VPWR VGND VPWR VGND sky130_fd_sc_hd__a41oi_2
Xsky130_fd_sc_hd__clkbuf_4_9 sky130_fd_sc_hd__clkbuf_4_9/X sky130_fd_sc_hd__clkbuf_4_9/A
+ VGND VPWR sky130_fd_sc_hd__clkbuf_4_9/VPB VGND sky130_fd_sc_hd__clkbuf_4
Xsky130_fd_sc_hd__xor2_2_1 sky130_fd_sc_hd__xor2_2_1/X sky130_fd_sc_hd__xor2_2_1/B
+ sky130_fd_sc_hd__or4_2_4/C VPWR VGND VPWR VGND sky130_fd_sc_hd__xor2_2
Xsky130_fd_sc_hd__and3_2_3 sky130_fd_sc_hd__and3_2_3/B sky130_fd_sc_hd__and3_2_3/X
+ sky130_fd_sc_hd__or4_2_0/B sky130_fd_sc_hd__and3_2_3/C VPWR VGND sky130_fd_sc_hd__and3_2_3/VPB
+ VGND sky130_fd_sc_hd__and3_2
Xsky130_fd_sc_hd__a221o_2_4 sky130_fd_sc_hd__a221o_2_4/X sky130_fd_sc_hd__nor2_2_39/Y
+ sky130_fd_sc_hd__inv_2_7/A sky130_fd_sc_hd__xor2_2_14/B sky130_fd_sc_hd__xor2_2_19/A
+ VGND VPWR sky130_fd_sc_hd__o21a_2_14/X VPWR VGND sky130_fd_sc_hd__a221o_2
Xsky130_fd_sc_hd__o21a_2_23 sky130_fd_sc_hd__o21a_2_23/A1 sky130_fd_sc_hd__a31o_2_19/X
+ sky130_fd_sc_hd__nand4_2_8/Y sky130_fd_sc_hd__o21a_2_23/X VGND VPWR VPWR VGND sky130_fd_sc_hd__o21a_2
Xsky130_fd_sc_hd__o21a_2_12 sky130_fd_sc_hd__o21a_2_12/A1 sky130_fd_sc_hd__a31o_2_9/X
+ sky130_fd_sc_hd__xnor2_2_11/B sky130_fd_sc_hd__o21a_2_12/X VGND VPWR VPWR VGND sky130_fd_sc_hd__o21a_2
Xsky130_fd_sc_hd__and2_2_13 sky130_fd_sc_hd__or4_2_8/A sky130_fd_sc_hd__and4_2_5/B
+ sky130_fd_sc_hd__or4_2_8/B VPWR VGND VPWR VGND sky130_fd_sc_hd__and2_2
Xsky130_fd_sc_hd__and2b_2_14 sky130_fd_sc_hd__o31a_2_2/A2 sky130_fd_sc_hd__or3b_2_0/A
+ sky130_fd_sc_hd__or2_2_9/A VPWR VGND VPWR VGND sky130_fd_sc_hd__and2b_2
Xsky130_fd_sc_hd__and2b_2_25 sky130_fd_sc_hd__and4_2_5/A sky130_fd_sc_hd__o21a_2_21/A1
+ sky130_fd_sc_hd__nand4_2_9/C VPWR VGND VPWR VGND sky130_fd_sc_hd__and2b_2
Xsky130_fd_sc_hd__a211o_2_3 sky130_fd_sc_hd__a211o_2_3/X sky130_fd_sc_hd__or2_2_9/B
+ sky130_fd_sc_hd__or3b_2_0/A sky130_fd_sc_hd__inv_2_13/Y sky130_fd_sc_hd__o31a_2_1/A3
+ VGND VPWR VPWR VGND sky130_fd_sc_hd__a211o_2
Xsky130_fd_sc_hd__decap_3_7 VPWR VGND VPWR VGND sky130_fd_sc_hd__decap_3
Xsky130_fd_sc_hd__dfxtp_2_3 sky130_fd_sc_hd__or2_2_9/B sky130_fd_sc_hd__dfxtp_2_3/CLK
+ sky130_fd_sc_hd__dfxtp_2_3/D VPWR VGND VPWR VGND sky130_fd_sc_hd__dfxtp_2
Xsky130_fd_sc_hd__a21oi_2_17 sky130_fd_sc_hd__or2_2_8/B sky130_fd_sc_hd__and3_2_17/C
+ sky130_fd_sc_hd__or3b_2_0/A sky130_fd_sc_hd__a22o_2_7/A1 VGND VPWR VPWR VGND sky130_fd_sc_hd__a21oi_2
Xsky130_fd_sc_hd__dfrtp_2_15 sky130_fd_sc_hd__xor2_2_0/B rst_n sky130_fd_sc_hd__o211a_2_7/X
+ sky130_fd_sc_hd__clkbuf_8_4/X VGND VPWR VPWR VGND sky130_fd_sc_hd__dfrtp_2
Xsky130_fd_sc_hd__dfrtp_2_48 sky130_fd_sc_hd__xor2_2_14/B rst_n sky130_fd_sc_hd__a221o_2_4/X
+ sky130_fd_sc_hd__clkbuf_8_7/X VGND VPWR VPWR VGND sky130_fd_sc_hd__dfrtp_2
Xsky130_fd_sc_hd__dfrtp_2_26 sky130_fd_sc_hd__or3_2_8/B rst_n sky130_fd_sc_hd__o21a_2_11/X
+ sky130_fd_sc_hd__clkbuf_8_3/X VGND VPWR VPWR VGND sky130_fd_sc_hd__dfrtp_2
Xsky130_fd_sc_hd__dfrtp_2_59 sky130_fd_sc_hd__o21a_2_16/A1 rst_n sky130_fd_sc_hd__dfrtp_2_59/D
+ sky130_fd_sc_hd__clkbuf_4_9/A VGND VPWR VPWR VGND sky130_fd_sc_hd__dfrtp_2
Xsky130_fd_sc_hd__dfrtp_2_37 sky130_fd_sc_hd__inv_2_11/A rst_n sky130_fd_sc_hd__a31o_2_12/X
+ sky130_fd_sc_hd__clkbuf_8_6/X VGND VPWR VPWR VGND sky130_fd_sc_hd__dfrtp_2
Xsky130_fd_sc_hd__inv_2_18 sky130_fd_sc_hd__inv_2_18/A sky130_fd_sc_hd__or4_2_7/B
+ VPWR VGND VPWR VGND sky130_fd_sc_hd__inv_2
Xsky130_fd_sc_hd__nand2_2_8 sky130_fd_sc_hd__xnor2_2_0/A sky130_fd_sc_hd__or4_2_4/B
+ sky130_fd_sc_hd__xor2_2_0/X VGND VPWR VPWR VGND sky130_fd_sc_hd__nand2_2
Xsky130_fd_sc_hd__inv_2_3 sky130_fd_sc_hd__inv_2_3/A sky130_fd_sc_hd__or4_2_3/B VPWR
+ VGND VPWR VGND sky130_fd_sc_hd__inv_2
Xsky130_fd_sc_hd__mux2_1_20 sky130_fd_sc_hd__or2_2_9/B sky130_fd_sc_hd__or2_2_8/B
+ sky130_fd_sc_hd__or2_2_9/A sky130_fd_sc_hd__mux2_1_20/X VGND VPWR sky130_fd_sc_hd__or2_2_8/VPB
+ VGND sky130_fd_sc_hd__mux2_1
Xsky130_fd_sc_hd__xor2_2_2 sky130_fd_sc_hd__or3_2_3/B sky130_fd_sc_hd__xor2_2_2/B
+ sky130_fd_sc_hd__xor2_2_2/A VPWR VGND VPWR VGND sky130_fd_sc_hd__xor2_2
Xsky130_fd_sc_hd__and3_2_4 sky130_fd_sc_hd__and3_2_4/B sky130_fd_sc_hd__and3_2_4/X
+ sky130_fd_sc_hd__and3_2_4/A sky130_fd_sc_hd__or3_2_5/X VPWR VGND VPWR VGND sky130_fd_sc_hd__and3_2
Xsky130_fd_sc_hd__a221o_2_5 sky130_fd_sc_hd__dfstp_2_0/D sky130_fd_sc_hd__xor2_2_17/B
+ sky130_fd_sc_hd__inv_2_7/A sky130_fd_sc_hd__nor2_2_39/Y sky130_fd_sc_hd__a22o_2_4/B2
+ VGND VPWR sky130_fd_sc_hd__nor2_2_40/Y VPWR VGND sky130_fd_sc_hd__a221o_2
Xsky130_fd_sc_hd__o21a_2_24 sky130_fd_sc_hd__o21a_2_24/A1 sky130_fd_sc_hd__a31o_2_20/X
+ sky130_fd_sc_hd__o21a_2_24/A2 sky130_fd_sc_hd__o21a_2_24/X VGND VPWR VPWR VGND sky130_fd_sc_hd__o21a_2
Xsky130_fd_sc_hd__o21a_2_13 sky130_fd_sc_hd__inv_2_15/Y sky130_fd_sc_hd__inv_2_14/Y
+ sky130_fd_sc_hd__o31a_2_2/A1 sky130_fd_sc_hd__o21a_2_13/X VGND VPWR VPWR VGND sky130_fd_sc_hd__o21a_2
Xsky130_fd_sc_hd__and2_2_14 sky130_fd_sc_hd__or4_2_6/A sky130_fd_sc_hd__and3_2_12/B
+ sky130_fd_sc_hd__or4_2_6/B VPWR VGND VPWR VGND sky130_fd_sc_hd__and2_2
Xsky130_fd_sc_hd__a32o_2_0 sky130_fd_sc_hd__xor2_2_3/B sky130_fd_sc_hd__xor2_2_2/A
+ sky130_fd_sc_hd__xor2_2_0/X sky130_fd_sc_hd__xor2_2_1/X sky130_fd_sc_hd__or4_2_4/B
+ sky130_fd_sc_hd__xor2_2_3/A VGND VPWR VPWR VGND sky130_fd_sc_hd__a32o_2
Xsky130_fd_sc_hd__and2b_2_26 sky130_fd_sc_hd__and4_2_5/D sky130_fd_sc_hd__o21a_2_28/A1
+ sky130_fd_sc_hd__nand4_2_10/C VPWR VGND VPWR VGND sky130_fd_sc_hd__and2b_2
Xsky130_fd_sc_hd__and2b_2_15 sky130_fd_sc_hd__o32a_2_2/B1 sky130_fd_sc_hd__nand2_2_29/Y
+ sky130_fd_sc_hd__or3_2_9/B VPWR VGND sky130_fd_sc_hd__nor2_2_34/VPB VGND sky130_fd_sc_hd__and2b_2
Xsky130_fd_sc_hd__a211o_2_4 sky130_fd_sc_hd__or3_2_15/A sky130_fd_sc_hd__or3_2_17/A
+ sky130_fd_sc_hd__or2_2_9/A sky130_fd_sc_hd__or3_2_6/C sky130_fd_sc_hd__or3_2_6/B
+ VGND VPWR VPWR VGND sky130_fd_sc_hd__a211o_2
Xsky130_fd_sc_hd__decap_3_8 VPWR VGND VPWR VGND sky130_fd_sc_hd__decap_3
Xsky130_fd_sc_hd__a21oi_2_18 sky130_fd_sc_hd__nor3_2_3/A sky130_fd_sc_hd__nor3_2_3/C
+ sky130_fd_sc_hd__nor3_2_3/B sky130_fd_sc_hd__or3_2_17/C VGND VPWR VPWR VGND sky130_fd_sc_hd__a21oi_2
Xsky130_fd_sc_hd__dfrtp_2_16 sky130_fd_sc_hd__xor2_2_7/A rst_n sky130_fd_sc_hd__mux2_1_5/X
+ sky130_fd_sc_hd__clkbuf_8_3/X VGND VPWR VPWR VGND sky130_fd_sc_hd__dfrtp_2
Xsky130_fd_sc_hd__dfrtp_2_49 sky130_fd_sc_hd__a22o_2_4/B2 rst_n sky130_fd_sc_hd__a31o_2_14/X
+ sky130_fd_sc_hd__clkbuf_4_9/A VGND VPWR VPWR VGND sky130_fd_sc_hd__dfrtp_2
Xsky130_fd_sc_hd__dfrtp_2_27 sky130_fd_sc_hd__or2_2_7/A rst_n sky130_fd_sc_hd__a22o_2_1/X
+ sky130_fd_sc_hd__clkbuf_8_4/X VGND VPWR VPWR VGND sky130_fd_sc_hd__dfrtp_2
Xsky130_fd_sc_hd__dfrtp_2_38 sky130_fd_sc_hd__a22o_2_2/B2 rst_n sky130_fd_sc_hd__mux2_1_11/X
+ sky130_fd_sc_hd__clkbuf_8_6/X VGND VPWR VPWR VGND sky130_fd_sc_hd__dfrtp_2
Xsky130_fd_sc_hd__inv_2_19 sky130_fd_sc_hd__inv_2_19/A sky130_fd_sc_hd__or4_2_8/B
+ VPWR VGND VPWR VGND sky130_fd_sc_hd__inv_2
Xsky130_fd_sc_hd__nand2_2_9 sky130_fd_sc_hd__nand2_2_9/Y sky130_fd_sc_hd__xor2_2_3/A
+ sky130_fd_sc_hd__inv_2_4/A VGND VPWR VPWR VGND sky130_fd_sc_hd__nand2_2
Xsky130_fd_sc_hd__or3_2_0 sky130_fd_sc_hd__or3_2_3/A sky130_fd_sc_hd__or3_2_0/B sky130_fd_sc_hd__or3_2_0/X
+ sky130_fd_sc_hd__or3_2_2/B VGND VPWR VPWR VGND sky130_fd_sc_hd__or3_2
Xsky130_fd_sc_hd__inv_2_4 sky130_fd_sc_hd__inv_2_4/A sky130_fd_sc_hd__inv_2_4/Y VPWR
+ VGND VPWR VGND sky130_fd_sc_hd__inv_2
Xsky130_fd_sc_hd__mux2_1_10 sky130_fd_sc_hd__inv_2_7/A sky130_fd_sc_hd__mux2_1_8/A0
+ sky130_fd_sc_hd__mux2_1_12/A1 sky130_fd_sc_hd__mux2_1_10/X VGND VPWR VPWR VGND sky130_fd_sc_hd__mux2_1
Xsky130_fd_sc_hd__xor2_2_3 sky130_fd_sc_hd__or2_2_2/A sky130_fd_sc_hd__xor2_2_3/B
+ sky130_fd_sc_hd__xor2_2_3/A VPWR VGND VPWR VGND sky130_fd_sc_hd__xor2_2
Xsky130_fd_sc_hd__and3_2_5 sky130_fd_sc_hd__and3_2_5/B sky130_fd_sc_hd__and3_2_6/C
+ sky130_fd_sc_hd__and3_2_5/A sky130_fd_sc_hd__and3_2_5/C VPWR VGND sky130_fd_sc_hd__and4_2_0/VPB
+ VGND sky130_fd_sc_hd__and3_2
Xsky130_fd_sc_hd__o21a_2_25 sky130_fd_sc_hd__o21a_2_25/A1 sky130_fd_sc_hd__a31o_2_21/X
+ sky130_fd_sc_hd__o21a_2_25/A2 sky130_fd_sc_hd__o21a_2_25/X VGND VPWR VPWR VGND sky130_fd_sc_hd__o21a_2
Xsky130_fd_sc_hd__o21a_2_14 sky130_fd_sc_hd__xor2_2_13/X sky130_fd_sc_hd__o21a_2_14/B1
+ sky130_fd_sc_hd__xor2_2_14/X sky130_fd_sc_hd__o21a_2_14/X VGND VPWR VPWR VGND sky130_fd_sc_hd__o21a_2
Xsky130_fd_sc_hd__and2_2_15 sky130_fd_sc_hd__inv_2_6/Y sky130_fd_sc_hd__and2_2_15/X
+ sky130_fd_sc_hd__and4_2_3/X VPWR VGND sky130_fd_sc_hd__diode_2_9/VPB VGND sky130_fd_sc_hd__and2_2
Xsky130_fd_sc_hd__a32o_2_1 sky130_fd_sc_hd__a32o_2_1/B2 sky130_fd_sc_hd__a32o_2_1/X
+ sky130_fd_sc_hd__o21a_2_3/A2 sky130_fd_sc_hd__or2_2_4/X sky130_fd_sc_hd__or4_2_0/A
+ sky130_fd_sc_hd__o22a_2_0/X VGND VPWR VPWR VGND sky130_fd_sc_hd__a32o_2
Xsky130_fd_sc_hd__and2b_2_27 sky130_fd_sc_hd__and3_2_12/C sky130_fd_sc_hd__o21a_2_25/A1
+ sky130_fd_sc_hd__nand4_2_13/C VPWR VGND VPWR VGND sky130_fd_sc_hd__and2b_2
Xsky130_fd_sc_hd__and2b_2_16 sky130_fd_sc_hd__and2b_2_16/X sky130_fd_sc_hd__or2_2_10/A
+ sky130_fd_sc_hd__inv_2_7/A VPWR VGND VPWR VGND sky130_fd_sc_hd__and2b_2
Xsky130_fd_sc_hd__decap_3_9 VPWR VGND VPWR VGND sky130_fd_sc_hd__decap_3
Xsky130_fd_sc_hd__decap_3_190 VPWR VGND sky130_fd_sc_hd__decap_3_190/VPB VGND sky130_fd_sc_hd__decap_3
Xsky130_fd_sc_hd__a21oi_2_19 sky130_fd_sc_hd__nor2_2_46/A sky130_fd_sc_hd__xor2_2_14/X
+ sky130_fd_sc_hd__xor2_2_13/X sky130_fd_sc_hd__o21a_2_14/B1 VGND VPWR VPWR VGND sky130_fd_sc_hd__a21oi_2
Xsky130_fd_sc_hd__a22o_2_0 sky130_fd_sc_hd__nand2_2_5/Y sky130_fd_sc_hd__or3_2_4/B
+ sky130_fd_sc_hd__a22o_2_0/X sky130_fd_sc_hd__or2_2_4/A sky130_fd_sc_hd__or3_2_3/C
+ VPWR VGND VPWR VGND sky130_fd_sc_hd__a22o_2
Xsky130_fd_sc_hd__dfrtp_2_28 sky130_fd_sc_hd__inv_2_6/A rst_n sky130_fd_sc_hd__a31o_2_11/X
+ sky130_fd_sc_hd__clkbuf_8_4/X VGND VPWR VPWR VGND sky130_fd_sc_hd__dfrtp_2
Xsky130_fd_sc_hd__dfrtp_2_17 sky130_fd_sc_hd__xor2_2_9/A rst_n sky130_fd_sc_hd__xor2_2_9/X
+ sky130_fd_sc_hd__clkbuf_8_4/X VGND VPWR VPWR VGND sky130_fd_sc_hd__dfrtp_2
Xsky130_fd_sc_hd__dfrtp_2_39 sky130_fd_sc_hd__mux2_1_19/A0 rst_n sky130_fd_sc_hd__mux2_1_19/X
+ sky130_fd_sc_hd__clkbuf_8_8/X VGND VPWR sky130_fd_sc_hd__dfrtp_2_39/VPB VGND sky130_fd_sc_hd__dfrtp_2
Xsky130_fd_sc_hd__or3_2_1 sky130_fd_sc_hd__or4_2_0/A sky130_fd_sc_hd__or3_2_1/B sky130_fd_sc_hd__or3_2_1/X
+ sky130_fd_sc_hd__or3_2_1/C VGND VPWR VPWR VGND sky130_fd_sc_hd__or3_2
Xsky130_fd_sc_hd__inv_2_5 sky130_fd_sc_hd__inv_2_5/A sky130_fd_sc_hd__inv_2_5/Y VPWR
+ VGND VPWR VGND sky130_fd_sc_hd__inv_2
Xsky130_fd_sc_hd__mux2_1_11 sky130_fd_sc_hd__inv_2_7/A sky130_fd_sc_hd__mux2_1_12/A0
+ sky130_fd_sc_hd__a22o_2_2/B2 sky130_fd_sc_hd__mux2_1_11/X VGND VPWR VPWR VGND sky130_fd_sc_hd__mux2_1
Xsky130_fd_sc_hd__xor2_2_4 sky130_fd_sc_hd__xor2_2_4/X sky130_fd_sc_hd__xor2_2_7/X
+ sky130_fd_sc_hd__xor2_2_4/A VPWR VGND VPWR VGND sky130_fd_sc_hd__xor2_2
Xsky130_fd_sc_hd__and3_2_6 sky130_fd_sc_hd__and4_2_0/X sky130_fd_sc_hd__and3_2_6/X
+ sky130_fd_sc_hd__and4_2_1/X sky130_fd_sc_hd__and3_2_6/C VPWR VGND sky130_fd_sc_hd__and4_2_0/VPB
+ VGND sky130_fd_sc_hd__and3_2
Xsky130_fd_sc_hd__o21a_2_15 sky130_fd_sc_hd__or2_2_9/A sky130_fd_sc_hd__o21ai_2_5/Y
+ sky130_fd_sc_hd__o21a_2_15/A2 sky130_fd_sc_hd__o21a_2_15/X VGND VPWR sky130_fd_sc_hd__o31a_2_2/VPB
+ VGND sky130_fd_sc_hd__o21a_2
Xsky130_fd_sc_hd__o21a_2_26 sky130_fd_sc_hd__inv_2_20/A sky130_fd_sc_hd__or4_2_6/X
+ sky130_fd_sc_hd__nor2_2_45/Y sky130_fd_sc_hd__o21a_2_26/X VGND VPWR VPWR VGND sky130_fd_sc_hd__o21a_2
Xsky130_fd_sc_hd__and2_2_16 sky130_fd_sc_hd__or2_2_11/B sky130_fd_sc_hd__or2_2_10/A
+ sky130_fd_sc_hd__and3_2_25/C VPWR VGND sky130_fd_sc_hd__and2_2_16/VPB VGND sky130_fd_sc_hd__and2_2
Xsky130_fd_sc_hd__a32o_2_2 sky130_fd_sc_hd__and4_2_3/A sky130_fd_sc_hd__a32o_2_2/X
+ sky130_fd_sc_hd__inv_2_7/A sky130_fd_sc_hd__and3_2_10/B I sky130_fd_sc_hd__inv_2_10/Y
+ VGND VPWR VPWR VGND sky130_fd_sc_hd__a32o_2
Xsky130_fd_sc_hd__and2b_2_28 sky130_fd_sc_hd__and4_2_5/C sky130_fd_sc_hd__o21a_2_24/A1
+ sky130_fd_sc_hd__nand4_2_11/C VPWR VGND VPWR VGND sky130_fd_sc_hd__and2b_2
Xsky130_fd_sc_hd__and2b_2_17 sky130_fd_sc_hd__o31a_2_1/A3 sky130_fd_sc_hd__or2_2_9/A
+ sky130_fd_sc_hd__or3b_2_0/A VPWR VGND VPWR VGND sky130_fd_sc_hd__and2b_2
Xsky130_fd_sc_hd__nand2_2_30 sky130_fd_sc_hd__o31a_2_1/B1 sky130_fd_sc_hd__or2_2_9/A
+ sky130_fd_sc_hd__or2_2_8/B VGND VPWR VPWR VGND sky130_fd_sc_hd__nand2_2
Xsky130_fd_sc_hd__diode_2_0 sky130_fd_sc_hd__or4b_2_3/B VGND VPWR VPWR VGND sky130_fd_sc_hd__diode_2
Xsky130_fd_sc_hd__decap_3_191 VPWR VGND sky130_fd_sc_hd__decap_3_191/VPB VGND sky130_fd_sc_hd__decap_3
Xsky130_fd_sc_hd__decap_3_180 VPWR VGND sky130_fd_sc_hd__decap_3_180/VPB VGND sky130_fd_sc_hd__decap_3
Xsky130_fd_sc_hd__dfrtp_2_18 sky130_fd_sc_hd__xor2_2_4/A rst_n sky130_fd_sc_hd__o311a_2_1/X
+ sky130_fd_sc_hd__clkbuf_8_4/X VGND VPWR VPWR VGND sky130_fd_sc_hd__dfrtp_2
Xsky130_fd_sc_hd__dfrtp_2_29 sky130_fd_sc_hd__inv_2_8/A rst_n sky130_fd_sc_hd__dfrtp_2_29/D
+ sky130_fd_sc_hd__clkbuf_8_4/X VGND VPWR VPWR VGND sky130_fd_sc_hd__dfrtp_2
Xsky130_fd_sc_hd__a22o_2_1 sky130_fd_sc_hd__inv_2_7/Y sky130_fd_sc_hd__or2_2_7/A sky130_fd_sc_hd__a22o_2_1/X
+ sky130_fd_sc_hd__inv_2_9/Y sky130_fd_sc_hd__o211a_2_8/X VPWR VGND VPWR VGND sky130_fd_sc_hd__a22o_2
Xsky130_fd_sc_hd__clkbuf_4_10 sky130_fd_sc_hd__clkbuf_4_10/X sky130_fd_sc_hd__clkbuf_8_9/X
+ VGND VPWR VPWR VGND sky130_fd_sc_hd__clkbuf_4
Xsky130_fd_sc_hd__or3_2_2 sky130_fd_sc_hd__or3_2_3/A sky130_fd_sc_hd__or3_2_2/B sky130_fd_sc_hd__or4_2_0/C
+ sky130_fd_sc_hd__or3_2_2/C VGND VPWR VPWR VGND sky130_fd_sc_hd__or3_2
Xsky130_fd_sc_hd__inv_2_6 sky130_fd_sc_hd__inv_2_6/A sky130_fd_sc_hd__inv_2_6/Y VPWR
+ VGND VPWR VGND sky130_fd_sc_hd__inv_2
Xsky130_fd_sc_hd__mux2_1_12 sky130_fd_sc_hd__inv_2_7/A sky130_fd_sc_hd__mux2_1_12/A1
+ sky130_fd_sc_hd__mux2_1_12/A0 sky130_fd_sc_hd__mux2_1_12/X VGND VPWR VPWR VGND sky130_fd_sc_hd__mux2_1
Xsky130_fd_sc_hd__a311o_2_0 sky130_fd_sc_hd__and3_2_3/B sky130_fd_sc_hd__and3_2_1/X
+ sky130_fd_sc_hd__or3_2_4/B sky130_fd_sc_hd__xor2_2_3/A sky130_fd_sc_hd__or4_2_0/A
+ sky130_fd_sc_hd__or2_2_0/B VGND VPWR VPWR VGND sky130_fd_sc_hd__a311o_2
Xsky130_fd_sc_hd__dfstp_2_0 sky130_fd_sc_hd__xor2_2_17/B sky130_fd_sc_hd__dfstp_2_0/D
+ VPWR rst_n sky130_fd_sc_hd__clkbuf_8_7/X VGND VPWR VGND sky130_fd_sc_hd__dfstp_2
Xsky130_fd_sc_hd__xor2_2_5 sky130_fd_sc_hd__xor2_2_5/X sky130_fd_sc_hd__xor2_2_5/B
+ sky130_fd_sc_hd__xor2_2_5/A VPWR VGND VPWR VGND sky130_fd_sc_hd__xor2_2
Xsky130_fd_sc_hd__and3_2_7 sky130_fd_sc_hd__inv_2_7/A sky130_fd_sc_hd__and3_2_7/X
+ sky130_fd_sc_hd__inv_2_9/A sky130_fd_sc_hd__and3_2_7/C VPWR VGND VPWR VGND sky130_fd_sc_hd__and3_2
Xsky130_fd_sc_hd__o21a_2_16 sky130_fd_sc_hd__o21a_2_16/A1 sky130_fd_sc_hd__a31o_2_17/X
+ sky130_fd_sc_hd__nand4_2_4/Y sky130_fd_sc_hd__o21a_2_16/X VGND VPWR VPWR VGND sky130_fd_sc_hd__o21a_2
Xsky130_fd_sc_hd__o21a_2_27 sky130_fd_sc_hd__o21a_2_27/A1 sky130_fd_sc_hd__a31o_2_22/X
+ sky130_fd_sc_hd__o21a_2_27/A2 sky130_fd_sc_hd__o21a_2_27/X VGND VPWR VPWR VGND sky130_fd_sc_hd__o21a_2
Xsky130_fd_sc_hd__a32o_2_3 sky130_fd_sc_hd__a32o_2_4/B2 sky130_fd_sc_hd__a32o_2_3/X
+ sky130_fd_sc_hd__and2_2_15/X sky130_fd_sc_hd__and4b_2_3/X sky130_fd_sc_hd__inv_2_23/Y
+ sky130_fd_sc_hd__a32o_2_3/B1 VGND VPWR VPWR VGND sky130_fd_sc_hd__a32o_2
Xsky130_fd_sc_hd__clkbuf_16_0 sky130_fd_sc_hd__clkbuf_8_9/A clk VGND VPWR VPWR VGND
+ sky130_fd_sc_hd__clkbuf_16
Xsky130_fd_sc_hd__and2b_2_29 sky130_fd_sc_hd__and3_2_12/A sky130_fd_sc_hd__o21a_2_27/A1
+ sky130_fd_sc_hd__nand4_2_12/C VPWR VGND VPWR VGND sky130_fd_sc_hd__and2b_2
Xsky130_fd_sc_hd__and2b_2_18 sky130_fd_sc_hd__o32a_2_3/A1 sky130_fd_sc_hd__nor2_2_34/Y
+ sky130_fd_sc_hd__xor2_2_16/X VPWR VGND VPWR VGND sky130_fd_sc_hd__and2b_2
Xsky130_fd_sc_hd__nand2_2_20 sky130_fd_sc_hd__and2_2_8/B sky130_fd_sc_hd__or2_2_9/B
+ sky130_fd_sc_hd__or2_2_8/B VGND VPWR sky130_fd_sc_hd__o22a_2_2/VPB VGND sky130_fd_sc_hd__nand2_2
Xsky130_fd_sc_hd__nand2_2_31 sky130_fd_sc_hd__xor2_2_20/B sky130_fd_sc_hd__nand2_2_31/A
+ sky130_fd_sc_hd__a22o_2_3/X VGND VPWR VPWR VGND sky130_fd_sc_hd__nand2_2
Xsky130_fd_sc_hd__decap_3_170 VPWR VGND sky130_fd_sc_hd__decap_3_176/VPB VGND sky130_fd_sc_hd__decap_3
Xsky130_fd_sc_hd__decap_3_192 VPWR VGND sky130_fd_sc_hd__decap_3_197/VPB VGND sky130_fd_sc_hd__decap_3
Xsky130_fd_sc_hd__decap_3_181 VPWR VGND sky130_fd_sc_hd__decap_3_181/VPB VGND sky130_fd_sc_hd__decap_3
Xsky130_fd_sc_hd__diode_2_1 enable VGND VPWR sky130_fd_sc_hd__diode_2_1/VPB VGND sky130_fd_sc_hd__diode_2
Xsky130_fd_sc_hd__dfrtp_2_19 sky130_fd_sc_hd__nor3_2_2/B rst_n sky130_fd_sc_hd__and2b_2_9/X
+ sky130_fd_sc_hd__clkbuf_8_3/X VGND VPWR VPWR VGND sky130_fd_sc_hd__dfrtp_2
Xsky130_fd_sc_hd__a22o_2_2 sky130_fd_sc_hd__or4_2_4/X sky130_fd_sc_hd__a22o_2_2/A2
+ sky130_fd_sc_hd__a22o_2_2/X sky130_fd_sc_hd__a22o_2_2/B2 sky130_fd_sc_hd__buf_2_0/X
+ VPWR VGND VPWR VGND sky130_fd_sc_hd__a22o_2
Xsky130_fd_sc_hd__clkbuf_4_11 sky130_fd_sc_hd__clkbuf_4_11/X sky130_fd_sc_hd__clkbuf_8_11/X
+ VGND VPWR VPWR VGND sky130_fd_sc_hd__clkbuf_4
Xsky130_fd_sc_hd__o31a_2_10 sky130_fd_sc_hd__o31a_2_10/X sky130_fd_sc_hd__o31a_2_9/A1
+ sky130_fd_sc_hd__a22o_2_13/X sky130_fd_sc_hd__or3_2_15/X sky130_fd_sc_hd__a22o_2_17/X
+ VGND VPWR VPWR VGND sky130_fd_sc_hd__o31a_2
Xsky130_fd_sc_hd__or3_2_3 sky130_fd_sc_hd__or3_2_3/A sky130_fd_sc_hd__or3_2_3/B sky130_fd_sc_hd__or3_2_3/X
+ sky130_fd_sc_hd__or3_2_3/C VGND VPWR VPWR VGND sky130_fd_sc_hd__or3_2
Xsky130_fd_sc_hd__inv_2_7 sky130_fd_sc_hd__inv_2_7/A sky130_fd_sc_hd__inv_2_7/Y VPWR
+ VGND VPWR VGND sky130_fd_sc_hd__inv_2
Xsky130_fd_sc_hd__mux2_1_13 sky130_fd_sc_hd__inv_2_7/A I sky130_fd_sc_hd__a22o_2_2/A2
+ sky130_fd_sc_hd__mux2_1_13/X VGND VPWR VPWR VGND sky130_fd_sc_hd__mux2_1
Xsky130_fd_sc_hd__a311o_2_1 sky130_fd_sc_hd__o31a_2_0/B1 sky130_fd_sc_hd__and3b_2_0/C
+ sky130_fd_sc_hd__and2b_2_6/X sky130_fd_sc_hd__nor3_2_1/C sky130_fd_sc_hd__o32ai_2_0/B1
+ sky130_fd_sc_hd__nand2b_2_8/Y VGND VPWR VPWR VGND sky130_fd_sc_hd__a311o_2
Xsky130_fd_sc_hd__dfstp_2_1 sky130_fd_sc_hd__xor2_2_16/A sky130_fd_sc_hd__o221a_2_1/X
+ VPWR rst_n sky130_fd_sc_hd__dfxtp_2_3/CLK VGND VPWR VGND sky130_fd_sc_hd__dfstp_2
Xsky130_fd_sc_hd__o31a_2_0 sky130_fd_sc_hd__o31a_2_0/X sky130_fd_sc_hd__o31a_2_0/A1
+ sky130_fd_sc_hd__o31a_2_0/A2 sky130_fd_sc_hd__o31a_2_0/B1 sky130_fd_sc_hd__nor3_2_1/Y
+ VGND VPWR sky130_fd_sc_hd__o31a_2_0/VPB VGND sky130_fd_sc_hd__o31a_2
Xsky130_fd_sc_hd__xor2_2_6 sky130_fd_sc_hd__or2_2_5/A sky130_fd_sc_hd__xor2_2_6/B
+ sky130_fd_sc_hd__xor2_2_6/A VPWR VGND VPWR VGND sky130_fd_sc_hd__xor2_2
Xsky130_fd_sc_hd__and3_2_8 sky130_fd_sc_hd__and4_2_3/B sky130_fd_sc_hd__and4_2_4/D
+ sky130_fd_sc_hd__and4_2_3/A sky130_fd_sc_hd__or3_2_8/B VPWR VGND VPWR VGND sky130_fd_sc_hd__and3_2
Xsky130_fd_sc_hd__dfrtp_2_0 sky130_fd_sc_hd__nand4_2_0/C rst_n sky130_fd_sc_hd__o21a_2_4/X
+ sky130_fd_sc_hd__clkbuf_8_0/X VGND VPWR sky130_fd_sc_hd__nand4_2_0/VPB VGND sky130_fd_sc_hd__dfrtp_2
Xsky130_fd_sc_hd__o21a_2_28 sky130_fd_sc_hd__o21a_2_28/A1 sky130_fd_sc_hd__a31o_2_23/X
+ sky130_fd_sc_hd__o21a_2_28/A2 sky130_fd_sc_hd__o21a_2_28/X VGND VPWR VPWR VGND sky130_fd_sc_hd__o21a_2
Xsky130_fd_sc_hd__o21a_2_17 sky130_fd_sc_hd__inv_2_16/A sky130_fd_sc_hd__or4_2_5/X
+ sky130_fd_sc_hd__nor2_2_42/Y sky130_fd_sc_hd__o21a_2_17/X VGND VPWR VPWR VGND sky130_fd_sc_hd__o21a_2
Xsky130_fd_sc_hd__a32o_2_4 sky130_fd_sc_hd__a32o_2_4/B2 sky130_fd_sc_hd__a32o_2_4/X
+ sky130_fd_sc_hd__and2_2_15/X sky130_fd_sc_hd__and4b_2_3/X sky130_fd_sc_hd__inv_2_23/A
+ success VGND VPWR VPWR VGND sky130_fd_sc_hd__a32o_2
Xsky130_fd_sc_hd__and2b_2_19 sky130_fd_sc_hd__and2b_2_19/X sky130_fd_sc_hd__o221a_2_2/C1
+ sky130_fd_sc_hd__or2_2_8/X VPWR VGND VPWR VGND sky130_fd_sc_hd__and2b_2
Xsky130_fd_sc_hd__a22o_2_20 sky130_fd_sc_hd__xnor2_2_13/Y sky130_fd_sc_hd__or3_2_17/B
+ sky130_fd_sc_hd__o31a_2_3/A3 sky130_fd_sc_hd__conb_1_0/LO sky130_fd_sc_hd__nor3b_2_3/Y
+ VPWR VGND VPWR VGND sky130_fd_sc_hd__a22o_2
Xsky130_fd_sc_hd__nand2_2_10 sky130_fd_sc_hd__a31o_2_5/A3 sky130_fd_sc_hd__or4_2_0/A
+ sky130_fd_sc_hd__o31ai_2_1/Y VGND VPWR VPWR VGND sky130_fd_sc_hd__nand2_2
Xsky130_fd_sc_hd__nand2_2_21 sky130_fd_sc_hd__and3_2_2/A sky130_fd_sc_hd__xor2_2_7/A
+ sky130_fd_sc_hd__xor2_2_9/A VGND VPWR VPWR VGND sky130_fd_sc_hd__nand2_2
Xsky130_fd_sc_hd__nand2_2_32 sky130_fd_sc_hd__inv_2_12/A sky130_fd_sc_hd__or2_2_9/B
+ sky130_fd_sc_hd__o31a_2_1/A3 VGND VPWR VPWR VGND sky130_fd_sc_hd__nand2_2
Xsky130_fd_sc_hd__decap_3_160 VPWR VGND sky130_fd_sc_hd__decap_3_166/VPB VGND sky130_fd_sc_hd__decap_3
Xsky130_fd_sc_hd__decap_3_193 VPWR VGND sky130_fd_sc_hd__decap_3_195/VPB VGND sky130_fd_sc_hd__decap_3
Xsky130_fd_sc_hd__diode_2_2 sky130_fd_sc_hd__conb_1_4/LO VGND VPWR sky130_fd_sc_hd__diode_2_2/VPB
+ VGND sky130_fd_sc_hd__diode_2
Xsky130_fd_sc_hd__decap_3_182 VPWR VGND sky130_fd_sc_hd__decap_3_182/VPB VGND sky130_fd_sc_hd__decap_3
Xsky130_fd_sc_hd__decap_3_171 VPWR VGND sky130_fd_sc_hd__decap_3_175/VPB VGND sky130_fd_sc_hd__decap_3
Xsky130_fd_sc_hd__a22o_2_3 sky130_fd_sc_hd__or3_2_9/A sky130_fd_sc_hd__or2_2_9/X sky130_fd_sc_hd__a22o_2_3/X
+ sky130_fd_sc_hd__or3b_2_0/X sky130_fd_sc_hd__o32a_2_2/A2 VPWR VGND VPWR VGND sky130_fd_sc_hd__a22o_2
Xsky130_fd_sc_hd__clkbuf_4_12 sky130_fd_sc_hd__clkbuf_4_12/X sky130_fd_sc_hd__clkbuf_8_10/X
+ VGND VPWR VPWR VGND sky130_fd_sc_hd__clkbuf_4
Xsky130_fd_sc_hd__or3_2_4 sky130_fd_sc_hd__or4_2_0/A sky130_fd_sc_hd__or3_2_4/B sky130_fd_sc_hd__or3_2_4/X
+ sky130_fd_sc_hd__or3_2_4/C VGND VPWR VPWR VGND sky130_fd_sc_hd__or3_2
Xsky130_fd_sc_hd__inv_2_8 sky130_fd_sc_hd__inv_2_8/A sky130_fd_sc_hd__inv_2_8/Y VPWR
+ VGND VPWR VGND sky130_fd_sc_hd__inv_2
Xsky130_fd_sc_hd__mux2_1_14 sky130_fd_sc_hd__inv_2_7/A sky130_fd_sc_hd__mux2_1_15/A0
+ sky130_fd_sc_hd__mux2_1_8/A1 sky130_fd_sc_hd__mux2_1_14/X VGND VPWR VPWR VGND sky130_fd_sc_hd__mux2_1
Xsky130_fd_sc_hd__dfstp_2_2 sky130_fd_sc_hd__xor2_2_20/A sky130_fd_sc_hd__dfstp_2_2/D
+ VPWR rst_n sky130_fd_sc_hd__clkbuf_8_7/X VGND VPWR VGND sky130_fd_sc_hd__dfstp_2
Xsky130_fd_sc_hd__o31a_2_1 sky130_fd_sc_hd__o31a_2_1/X sky130_fd_sc_hd__or2_2_9/B
+ sky130_fd_sc_hd__or3_2_9/A sky130_fd_sc_hd__o31a_2_1/B1 sky130_fd_sc_hd__o31a_2_1/A3
+ VGND VPWR VPWR VGND sky130_fd_sc_hd__o31a_2
Xsky130_fd_sc_hd__xor2_2_7 sky130_fd_sc_hd__xor2_2_7/X sky130_fd_sc_hd__xor2_2_9/A
+ sky130_fd_sc_hd__xor2_2_7/A VPWR VGND VPWR VGND sky130_fd_sc_hd__xor2_2
Xsky130_fd_sc_hd__and3_2_9 I sky130_fd_sc_hd__inv_2_10/A sky130_fd_sc_hd__or3_2_8/A
+ sky130_fd_sc_hd__inv_2_7/A VPWR VGND sky130_fd_sc_hd__and3_2_9/VPB VGND sky130_fd_sc_hd__and3_2
Xsky130_fd_sc_hd__dfrtp_2_1 sky130_fd_sc_hd__inv_2_1/A rst_n sky130_fd_sc_hd__o21a_2_7/X
+ sky130_fd_sc_hd__clkbuf_8_0/X VGND VPWR VPWR VGND sky130_fd_sc_hd__dfrtp_2
Xsky130_fd_sc_hd__o21a_2_29 sky130_fd_sc_hd__inv_2_17/A sky130_fd_sc_hd__or4_2_9/X
+ sky130_fd_sc_hd__nor2_2_41/Y sky130_fd_sc_hd__o21a_2_29/X VGND VPWR VPWR VGND sky130_fd_sc_hd__o21a_2
Xsky130_fd_sc_hd__o21a_2_18 sky130_fd_sc_hd__o21a_2_18/A1 sky130_fd_sc_hd__a31o_2_16/X
+ sky130_fd_sc_hd__nand4_2_6/Y sky130_fd_sc_hd__o21a_2_18/X VGND VPWR VPWR VGND sky130_fd_sc_hd__o21a_2
Xsky130_fd_sc_hd__o21a_2_0 sky130_fd_sc_hd__or3_2_3/A sky130_fd_sc_hd__or3_2_3/B sky130_fd_sc_hd__or3_2_3/C
+ sky130_fd_sc_hd__or4_2_0/D VGND VPWR VPWR VGND sky130_fd_sc_hd__o21a_2
Xsky130_fd_sc_hd__a22o_2_21 sky130_fd_sc_hd__o31a_2_2/X sky130_fd_sc_hd__nor3b_2_2/Y
+ sky130_fd_sc_hd__o31a_2_9/A2 sky130_fd_sc_hd__a22o_2_21/B2 sky130_fd_sc_hd__nor3_2_3/Y
+ VPWR VGND VPWR VGND sky130_fd_sc_hd__a22o_2
Xsky130_fd_sc_hd__a22o_2_10 sky130_fd_sc_hd__xnor2_2_14/Y sky130_fd_sc_hd__or3_2_17/B
+ sky130_fd_sc_hd__o31a_2_9/A3 sky130_fd_sc_hd__o21bai_2_0/Y sky130_fd_sc_hd__nor3b_2_3/Y
+ VPWR VGND VPWR VGND sky130_fd_sc_hd__a22o_2
Xsky130_fd_sc_hd__nand2_2_11 sky130_fd_sc_hd__o21a_2_3/A2 sky130_fd_sc_hd__or2_2_4/A
+ sky130_fd_sc_hd__nand2_2_5/Y VGND VPWR VPWR VGND sky130_fd_sc_hd__nand2_2
Xsky130_fd_sc_hd__nand2_2_33 sky130_fd_sc_hd__or4_2_9/D I sky130_fd_sc_hd__inv_2_7/A
+ VGND VPWR VPWR VGND sky130_fd_sc_hd__nand2_2
Xsky130_fd_sc_hd__nand2_2_22 sky130_fd_sc_hd__and3_2_2/B sky130_fd_sc_hd__xor2_2_4/A
+ sky130_fd_sc_hd__xor2_2_7/X VGND VPWR VPWR VGND sky130_fd_sc_hd__nand2_2
Xsky130_fd_sc_hd__decap_3_161 VPWR VGND VPWR VGND sky130_fd_sc_hd__decap_3
Xsky130_fd_sc_hd__decap_3_150 VPWR VGND sky130_fd_sc_hd__decap_3_150/VPB VGND sky130_fd_sc_hd__decap_3
Xsky130_fd_sc_hd__decap_3_194 VPWR VGND sky130_fd_sc_hd__decap_3_199/VPB VGND sky130_fd_sc_hd__decap_3
Xsky130_fd_sc_hd__diode_2_3 sky130_fd_sc_hd__and4_2_3/X VGND VPWR sky130_fd_sc_hd__diode_2_3/VPB
+ VGND sky130_fd_sc_hd__diode_2
Xsky130_fd_sc_hd__decap_3_183 VPWR VGND sky130_fd_sc_hd__decap_3_184/VPB VGND sky130_fd_sc_hd__decap_3
Xsky130_fd_sc_hd__decap_3_172 VPWR VGND sky130_fd_sc_hd__decap_3_173/VPB VGND sky130_fd_sc_hd__decap_3
Xsky130_fd_sc_hd__a22o_2_4 sky130_fd_sc_hd__inv_2_7/A sky130_fd_sc_hd__xor2_2_20/A
+ sky130_fd_sc_hd__a22o_2_4/X sky130_fd_sc_hd__a22o_2_4/B2 sky130_fd_sc_hd__nor2_2_39/Y
+ VPWR VGND VPWR VGND sky130_fd_sc_hd__a22o_2
Xsky130_fd_sc_hd__nand4_2_0 sky130_fd_sc_hd__inv_2_7/A I sky130_fd_sc_hd__o21a_2_4/A2
+ sky130_fd_sc_hd__nor4_2_0/Y sky130_fd_sc_hd__nand4_2_0/C VGND VPWR sky130_fd_sc_hd__nand4_2_0/VPB
+ VGND sky130_fd_sc_hd__nand4_2
Xsky130_fd_sc_hd__clkbuf_4_13 sky130_fd_sc_hd__clkbuf_4_13/X sky130_fd_sc_hd__dfxtp_2_2/CLK
+ VGND VPWR sky130_fd_sc_hd__clkbuf_8_12/VPB VGND sky130_fd_sc_hd__clkbuf_4
Xsky130_fd_sc_hd__or3_2_5 sky130_fd_sc_hd__or3_2_5/A sky130_fd_sc_hd__or3_2_5/B sky130_fd_sc_hd__or3_2_5/X
+ sky130_fd_sc_hd__or3_2_5/C VGND VPWR VPWR VGND sky130_fd_sc_hd__or3_2
Xsky130_fd_sc_hd__inv_2_9 sky130_fd_sc_hd__inv_2_9/A sky130_fd_sc_hd__inv_2_9/Y VPWR
+ VGND VPWR VGND sky130_fd_sc_hd__inv_2
Xsky130_fd_sc_hd__and3b_2_0 sky130_fd_sc_hd__and2_2_7/B sky130_fd_sc_hd__xnor2_2_6/A
+ sky130_fd_sc_hd__nor3_2_1/B sky130_fd_sc_hd__and3b_2_0/C VGND VPWR VPWR VGND sky130_fd_sc_hd__and3b_2
Xsky130_fd_sc_hd__nor2_2_0 sky130_fd_sc_hd__nor2_2_0/B sky130_fd_sc_hd__xor2_2_3/B
+ sky130_fd_sc_hd__nor2_2_8/A VGND VPWR VPWR VGND sky130_fd_sc_hd__nor2_2
Xsky130_fd_sc_hd__mux2_1_15 sky130_fd_sc_hd__inv_2_7/A sky130_fd_sc_hd__mux2_1_16/A0
+ sky130_fd_sc_hd__mux2_1_15/A0 sky130_fd_sc_hd__mux2_1_15/X VGND VPWR VPWR VGND sky130_fd_sc_hd__mux2_1
Xsky130_fd_sc_hd__dfstp_2_3 sky130_fd_sc_hd__or2_2_12/A sky130_fd_sc_hd__o32a_2_3/X
+ VPWR rst_n sky130_fd_sc_hd__clkbuf_8_7/X VGND VPWR VGND sky130_fd_sc_hd__dfstp_2
Xsky130_fd_sc_hd__o31a_2_2 sky130_fd_sc_hd__o31a_2_2/X sky130_fd_sc_hd__o31a_2_2/A1
+ sky130_fd_sc_hd__o31a_2_2/A2 sky130_fd_sc_hd__inv_2_14/Y sky130_fd_sc_hd__o31a_2_2/A3
+ VGND VPWR sky130_fd_sc_hd__o31a_2_2/VPB VGND sky130_fd_sc_hd__o31a_2
Xsky130_fd_sc_hd__nor2_2_40 sky130_fd_sc_hd__nor2_2_46/A sky130_fd_sc_hd__nor2_2_40/Y
+ sky130_fd_sc_hd__nor2_2_40/A VGND VPWR VPWR VGND sky130_fd_sc_hd__nor2_2
Xsky130_fd_sc_hd__xor2_2_8 sky130_fd_sc_hd__or4_2_0/A sky130_fd_sc_hd__xor2_2_8/B
+ sky130_fd_sc_hd__xor2_2_8/A VPWR VGND VPWR VGND sky130_fd_sc_hd__xor2_2
Xsky130_fd_sc_hd__dfrtp_2_2 sky130_fd_sc_hd__or4_2_1/A rst_n sky130_fd_sc_hd__a21o_2_0/X
+ sky130_fd_sc_hd__dfrtp_2_8/CLK VGND VPWR VPWR VGND sky130_fd_sc_hd__dfrtp_2
Xsky130_fd_sc_hd__o21a_2_19 sky130_fd_sc_hd__o21a_2_19/A1 sky130_fd_sc_hd__a31o_2_18/X
+ sky130_fd_sc_hd__nand4_2_7/Y sky130_fd_sc_hd__o21a_2_19/X VGND VPWR VPWR VGND sky130_fd_sc_hd__o21a_2
Xsky130_fd_sc_hd__o21a_2_1 sky130_fd_sc_hd__or3_2_3/B sky130_fd_sc_hd__or2_2_4/X sky130_fd_sc_hd__and2_2_2/X
+ sky130_fd_sc_hd__o21a_2_1/X VGND VPWR VPWR VGND sky130_fd_sc_hd__o21a_2
Xsky130_fd_sc_hd__xnor2_2_0 sky130_fd_sc_hd__xor2_2_3/A sky130_fd_sc_hd__xnor2_2_0/A
+ sky130_fd_sc_hd__xor2_2_1/X VGND VPWR VPWR VGND sky130_fd_sc_hd__xnor2_2
Xsky130_fd_sc_hd__a22o_2_11 sky130_fd_sc_hd__xnor2_2_18/Y sky130_fd_sc_hd__or3_2_17/B
+ sky130_fd_sc_hd__o31a_2_6/A3 sky130_fd_sc_hd__o31a_2_0/X sky130_fd_sc_hd__nor3b_2_3/Y
+ VPWR VGND VPWR VGND sky130_fd_sc_hd__a22o_2
Xsky130_fd_sc_hd__a22o_2_22 sky130_fd_sc_hd__or3b_2_0/A sky130_fd_sc_hd__or3_2_9/C
+ sky130_fd_sc_hd__a22o_2_22/X sky130_fd_sc_hd__or2_2_9/B sky130_fd_sc_hd__nand2_2_31/A
+ VPWR VGND VPWR VGND sky130_fd_sc_hd__a22o_2
Xsky130_fd_sc_hd__nand2_2_12 sky130_fd_sc_hd__o311a_2_0/C1 sky130_fd_sc_hd__or4_2_0/A
+ sky130_fd_sc_hd__mux2_1_1/X VGND VPWR VPWR VGND sky130_fd_sc_hd__nand2_2
Xsky130_fd_sc_hd__nand2_2_23 sky130_fd_sc_hd__mux2_1_5/A1 sky130_fd_sc_hd__inv_2_9/A
+ sky130_fd_sc_hd__inv_2_7/A VGND VPWR VPWR VGND sky130_fd_sc_hd__nand2_2
Xsky130_fd_sc_hd__nand2_2_34 sky130_fd_sc_hd__or4_2_5/D I sky130_fd_sc_hd__inv_2_7/A
+ VGND VPWR VPWR VGND sky130_fd_sc_hd__nand2_2
Xsky130_fd_sc_hd__decap_3_140 VPWR VGND sky130_fd_sc_hd__decap_3_145/VPB VGND sky130_fd_sc_hd__decap_3
Xsky130_fd_sc_hd__decap_3_151 VPWR VGND sky130_fd_sc_hd__decap_3_152/VPB VGND sky130_fd_sc_hd__decap_3
Xsky130_fd_sc_hd__decap_3_195 VPWR VGND sky130_fd_sc_hd__decap_3_195/VPB VGND sky130_fd_sc_hd__decap_3
Xsky130_fd_sc_hd__diode_2_4 sky130_fd_sc_hd__and3_2_6/X VGND VPWR sky130_fd_sc_hd__diode_2_4/VPB
+ VGND sky130_fd_sc_hd__diode_2
Xsky130_fd_sc_hd__decap_3_184 VPWR VGND sky130_fd_sc_hd__decap_3_184/VPB VGND sky130_fd_sc_hd__decap_3
Xsky130_fd_sc_hd__decap_3_173 VPWR VGND sky130_fd_sc_hd__decap_3_173/VPB VGND sky130_fd_sc_hd__decap_3
Xsky130_fd_sc_hd__decap_3_162 VPWR VGND sky130_fd_sc_hd__decap_3_164/VPB VGND sky130_fd_sc_hd__decap_3
Xsky130_fd_sc_hd__a22o_2_5 sky130_fd_sc_hd__inv_2_7/A sky130_fd_sc_hd__xor2_2_14/B
+ sky130_fd_sc_hd__a22o_2_5/X sky130_fd_sc_hd__nor2_2_39/Y sky130_fd_sc_hd__xor2_2_20/A
+ VPWR VGND VPWR VGND sky130_fd_sc_hd__a22o_2
Xsky130_fd_sc_hd__nand4_2_1 sky130_fd_sc_hd__inv_2_7/A I sky130_fd_sc_hd__nand4_2_1/Y
+ sky130_fd_sc_hd__nand4_2_1/D sky130_fd_sc_hd__nand4_2_1/C VGND VPWR VPWR VGND sky130_fd_sc_hd__nand4_2
Xsky130_fd_sc_hd__clkbuf_4_14 sky130_fd_sc_hd__clkbuf_4_14/X sky130_fd_sc_hd__dfrtp_2_8/CLK
+ VGND VPWR VPWR VGND sky130_fd_sc_hd__clkbuf_4
Xsky130_fd_sc_hd__a21o_2_10 sky130_fd_sc_hd__a21o_2_10/X sky130_fd_sc_hd__and4_2_3/B
+ sky130_fd_sc_hd__and4_2_3/A sky130_fd_sc_hd__inv_2_10/A VGND VPWR VPWR VGND sky130_fd_sc_hd__a21o_2
Xsky130_fd_sc_hd__or3_2_6 sky130_fd_sc_hd__or3_2_6/A sky130_fd_sc_hd__or3_2_6/B sky130_fd_sc_hd__or3_2_6/X
+ sky130_fd_sc_hd__or3_2_6/C VGND VPWR VPWR VGND sky130_fd_sc_hd__or3_2
Xsky130_fd_sc_hd__and3b_2_1 sky130_fd_sc_hd__or2_2_9/B sky130_fd_sc_hd__and3b_2_1/X
+ sky130_fd_sc_hd__or2_2_8/B sky130_fd_sc_hd__or2_2_9/A VGND VPWR VPWR VGND sky130_fd_sc_hd__and3b_2
Xsky130_fd_sc_hd__nor2_2_1 sky130_fd_sc_hd__or2_2_0/B sky130_fd_sc_hd__or3_2_2/B sky130_fd_sc_hd__nor2_2_4/Y
+ VGND VPWR VPWR VGND sky130_fd_sc_hd__nor2_2
Xsky130_fd_sc_hd__mux2_1_16 sky130_fd_sc_hd__inv_2_7/A sky130_fd_sc_hd__mux2_1_9/A0
+ sky130_fd_sc_hd__mux2_1_16/A0 sky130_fd_sc_hd__mux2_1_16/X VGND VPWR VPWR VGND sky130_fd_sc_hd__mux2_1
Xsky130_fd_sc_hd__nand2b_2_20 sky130_fd_sc_hd__o21a_2_27/A2 sky130_fd_sc_hd__dfrtp_2_70/D
+ sky130_fd_sc_hd__o21a_2_27/A1 VGND VPWR VPWR VGND sky130_fd_sc_hd__nand2b_2
Xsky130_fd_sc_hd__o31a_2_3 sky130_fd_sc_hd__o31a_2_3/X sky130_fd_sc_hd__o31a_2_9/A1
+ sky130_fd_sc_hd__a22o_2_6/X sky130_fd_sc_hd__or3_2_13/X sky130_fd_sc_hd__o31a_2_3/A3
+ VGND VPWR VPWR VGND sky130_fd_sc_hd__o31a_2
Xsky130_fd_sc_hd__nor2_2_41 sky130_fd_sc_hd__or4_2_9/D sky130_fd_sc_hd__nor2_2_41/Y
+ sky130_fd_sc_hd__or4_2_9/C VGND VPWR VPWR VGND sky130_fd_sc_hd__nor2_2
Xsky130_fd_sc_hd__nor2_2_30 sky130_fd_sc_hd__nor2_2_30/B sky130_fd_sc_hd__nor2_2_30/Y
+ sky130_fd_sc_hd__inv_2_10/A VGND VPWR VPWR VGND sky130_fd_sc_hd__nor2_2
Xsky130_fd_sc_hd__xor2_2_9 sky130_fd_sc_hd__xor2_2_9/X sky130_fd_sc_hd__inv_2_5/A
+ sky130_fd_sc_hd__xor2_2_9/A VPWR VGND VPWR VGND sky130_fd_sc_hd__xor2_2
Xsky130_fd_sc_hd__and2_2_0 sky130_fd_sc_hd__or2_2_1/X sky130_fd_sc_hd__and3_2_0/C
+ sky130_fd_sc_hd__or2_2_0/B VPWR VGND VPWR VGND sky130_fd_sc_hd__and2_2
Xsky130_fd_sc_hd__dfrtp_2_3 sky130_fd_sc_hd__or4_2_3/A rst_n sky130_fd_sc_hd__a21o_2_2/X
+ sky130_fd_sc_hd__clkbuf_8_0/X VGND VPWR VPWR VGND sky130_fd_sc_hd__dfrtp_2
Xsky130_fd_sc_hd__o21a_2_2 sky130_fd_sc_hd__or3_2_3/B sky130_fd_sc_hd__or2_2_4/B sky130_fd_sc_hd__inv_2_4/A
+ sky130_fd_sc_hd__or2_2_6/B VGND VPWR VPWR VGND sky130_fd_sc_hd__o21a_2
Xsky130_fd_sc_hd__xnor2_2_1 sky130_fd_sc_hd__nor2_2_8/A sky130_fd_sc_hd__or4_2_4/B
+ sky130_fd_sc_hd__xor2_2_0/X VGND VPWR VPWR VGND sky130_fd_sc_hd__xnor2_2
Xsky130_fd_sc_hd__a22o_2_12 sky130_fd_sc_hd__conb_1_4/LO sky130_fd_sc_hd__nor3b_2_2/Y
+ sky130_fd_sc_hd__o31a_2_5/A2 sky130_fd_sc_hd__o211a_2_9/X sky130_fd_sc_hd__nor3_2_3/Y
+ VPWR VGND VPWR VGND sky130_fd_sc_hd__a22o_2
Xsky130_fd_sc_hd__nand2_2_35 sky130_fd_sc_hd__or4_2_6/D I sky130_fd_sc_hd__inv_2_7/A
+ VGND VPWR VPWR VGND sky130_fd_sc_hd__nand2_2
Xsky130_fd_sc_hd__nand2_2_24 sky130_fd_sc_hd__xnor2_2_11/B sky130_fd_sc_hd__inv_2_10/A
+ sky130_fd_sc_hd__and4_2_4/D VGND VPWR VPWR VGND sky130_fd_sc_hd__nand2_2
Xsky130_fd_sc_hd__nand2_2_13 sky130_fd_sc_hd__or4_2_3/D I sky130_fd_sc_hd__inv_2_7/A
+ VGND VPWR VPWR VGND sky130_fd_sc_hd__nand2_2
Xsky130_fd_sc_hd__nor4b_2_0 sky130_fd_sc_hd__or2_2_8/B sky130_fd_sc_hd__or3_2_6/C
+ sky130_fd_sc_hd__or2_2_9/B sky130_fd_sc_hd__or3b_2_0/A sky130_fd_sc_hd__or2_2_9/A
+ VGND VPWR VPWR VGND sky130_fd_sc_hd__nor4b_2
Xsky130_fd_sc_hd__decap_3_130 VPWR VGND sky130_fd_sc_hd__decap_3_138/VPB VGND sky130_fd_sc_hd__decap_3
Xsky130_fd_sc_hd__decap_3_141 VPWR VGND sky130_fd_sc_hd__decap_3_146/VPB VGND sky130_fd_sc_hd__decap_3
Xsky130_fd_sc_hd__decap_3_152 VPWR VGND sky130_fd_sc_hd__decap_3_152/VPB VGND sky130_fd_sc_hd__decap_3
Xsky130_fd_sc_hd__diode_2_5 sky130_fd_sc_hd__and4_2_3/X VGND VPWR sky130_fd_sc_hd__diode_2_9/VPB
+ VGND sky130_fd_sc_hd__diode_2
Xsky130_fd_sc_hd__decap_3_185 VPWR VGND sky130_fd_sc_hd__decap_3_187/VPB VGND sky130_fd_sc_hd__decap_3
Xsky130_fd_sc_hd__decap_3_174 VPWR VGND sky130_fd_sc_hd__decap_3_201/VPB VGND sky130_fd_sc_hd__decap_3
Xsky130_fd_sc_hd__decap_3_163 VPWR VGND VPWR VGND sky130_fd_sc_hd__decap_3
Xsky130_fd_sc_hd__decap_3_196 VPWR VGND sky130_fd_sc_hd__decap_3_198/VPB VGND sky130_fd_sc_hd__decap_3
Xsky130_fd_sc_hd__a22o_2_6 sky130_fd_sc_hd__conb_1_5/LO sky130_fd_sc_hd__nor3b_2_2/Y
+ sky130_fd_sc_hd__a22o_2_6/X sky130_fd_sc_hd__conb_1_3/LO sky130_fd_sc_hd__nor3_2_3/Y
+ VPWR VGND VPWR VGND sky130_fd_sc_hd__a22o_2
Xsky130_fd_sc_hd__nand4_2_2 sky130_fd_sc_hd__inv_2_7/A I sky130_fd_sc_hd__o21a_2_8/A2
+ sky130_fd_sc_hd__nand4_2_2/D sky130_fd_sc_hd__nand4_2_2/C VGND VPWR VPWR VGND sky130_fd_sc_hd__nand4_2
Xsky130_fd_sc_hd__a21o_2_11 sky130_fd_sc_hd__dfstp_2_2/D sky130_fd_sc_hd__a22o_2_5/X
+ sky130_fd_sc_hd__and2b_2_16/X sky130_fd_sc_hd__xnor2_2_19/Y VGND VPWR VPWR VGND
+ sky130_fd_sc_hd__a21o_2
Xsky130_fd_sc_hd__or3_2_7 sky130_fd_sc_hd__or3_2_7/A sky130_fd_sc_hd__or3_2_7/B sky130_fd_sc_hd__or3_2_7/X
+ sky130_fd_sc_hd__or3_2_7/C VGND VPWR VPWR VGND sky130_fd_sc_hd__or3_2
Xsky130_fd_sc_hd__and3b_2_2 sky130_fd_sc_hd__nor2_2_32/B sky130_fd_sc_hd__and3b_2_2/X
+ sky130_fd_sc_hd__or2_2_8/B sky130_fd_sc_hd__or2_2_9/B VGND VPWR VPWR VGND sky130_fd_sc_hd__and3b_2
Xsky130_fd_sc_hd__nor2_2_2 sky130_fd_sc_hd__inv_2_4/A sky130_fd_sc_hd__or3_2_2/C sky130_fd_sc_hd__or3_2_0/B
+ VGND VPWR VPWR VGND sky130_fd_sc_hd__nor2_2
Xsky130_fd_sc_hd__mux2_1_17 sky130_fd_sc_hd__inv_2_7/A sky130_fd_sc_hd__mux2_1_19/A0
+ sky130_fd_sc_hd__mux2_1_9/A1 sky130_fd_sc_hd__mux2_1_17/X VGND VPWR VPWR VGND sky130_fd_sc_hd__mux2_1
Xsky130_fd_sc_hd__nand2b_2_21 sky130_fd_sc_hd__o21a_2_28/A2 sky130_fd_sc_hd__dfrtp_2_64/D
+ sky130_fd_sc_hd__o21a_2_28/A1 VGND VPWR VPWR VGND sky130_fd_sc_hd__nand2b_2
Xsky130_fd_sc_hd__nand2b_2_10 sky130_fd_sc_hd__or2_2_9/B sky130_fd_sc_hd__and2_2_7/B
+ sky130_fd_sc_hd__or3b_2_0/A VGND VPWR VPWR VGND sky130_fd_sc_hd__nand2b_2
Xsky130_fd_sc_hd__o31a_2_4 sky130_fd_sc_hd__o31a_2_4/X sky130_fd_sc_hd__o31a_2_9/A1
+ sky130_fd_sc_hd__a22o_2_7/X sky130_fd_sc_hd__or3_2_12/X sky130_fd_sc_hd__a22o_2_9/X
+ VGND VPWR VPWR VGND sky130_fd_sc_hd__o31a_2
Xsky130_fd_sc_hd__nor2_2_20 sky130_fd_sc_hd__o211a_2_0/X sky130_fd_sc_hd__nor2_2_20/Y
+ sky130_fd_sc_hd__nor2_2_20/A VGND VPWR sky130_fd_sc_hd__and3_2_3/VPB VGND sky130_fd_sc_hd__nor2_2
Xsky130_fd_sc_hd__nor2_2_31 sky130_fd_sc_hd__nor2_2_31/B sky130_fd_sc_hd__nor2_2_31/Y
+ sky130_fd_sc_hd__inv_2_9/A VGND VPWR VPWR VGND sky130_fd_sc_hd__nor2_2
Xsky130_fd_sc_hd__nor2_2_42 sky130_fd_sc_hd__or4_2_5/D sky130_fd_sc_hd__nor2_2_42/Y
+ sky130_fd_sc_hd__or4_2_5/C VGND VPWR VPWR VGND sky130_fd_sc_hd__nor2_2
Xsky130_fd_sc_hd__decap_3_90 VPWR VGND sky130_fd_sc_hd__decap_3_90/VPB VGND sky130_fd_sc_hd__decap_3
Xsky130_fd_sc_hd__and2_2_1 sky130_fd_sc_hd__or4_2_4/A sky130_fd_sc_hd__or2_2_1/A sky130_fd_sc_hd__xor2_2_7/A
+ VPWR VGND VPWR VGND sky130_fd_sc_hd__and2_2
Xsky130_fd_sc_hd__dfrtp_2_4 sky130_fd_sc_hd__o21a_2_5/A1 rst_n sky130_fd_sc_hd__dfrtp_2_4/D
+ sky130_fd_sc_hd__dfrtp_2_8/CLK VGND VPWR VPWR VGND sky130_fd_sc_hd__dfrtp_2
Xsky130_fd_sc_hd__o21a_2_3 sky130_fd_sc_hd__or3_2_3/A sky130_fd_sc_hd__or2_2_3/X sky130_fd_sc_hd__o21a_2_3/A2
+ sky130_fd_sc_hd__o21a_2_3/X VGND VPWR VPWR VGND sky130_fd_sc_hd__o21a_2
Xsky130_fd_sc_hd__xnor2_2_2 sky130_fd_sc_hd__or3_2_0/B sky130_fd_sc_hd__xor2_2_3/A
+ sky130_fd_sc_hd__xor2_2_3/B VGND VPWR VPWR VGND sky130_fd_sc_hd__xnor2_2
Xsky130_fd_sc_hd__a22o_2_13 sky130_fd_sc_hd__a22o_2_13/A1 sky130_fd_sc_hd__nor3b_2_2/Y
+ sky130_fd_sc_hd__a22o_2_13/X sky130_fd_sc_hd__o221a_2_2/X sky130_fd_sc_hd__nor3_2_3/Y
+ VPWR VGND VPWR VGND sky130_fd_sc_hd__a22o_2
Xsky130_fd_sc_hd__nand2_2_36 sky130_fd_sc_hd__or4_2_7/D I sky130_fd_sc_hd__inv_2_7/A
+ VGND VPWR VPWR VGND sky130_fd_sc_hd__nand2_2
Xsky130_fd_sc_hd__nor4b_2_1 sky130_fd_sc_hd__nor3_2_2/Y sky130_fd_sc_hd__or4b_2_8/A
+ sky130_fd_sc_hd__and4_2_3/C sky130_fd_sc_hd__and4_2_3/A sky130_fd_sc_hd__and4_2_3/B
+ VGND VPWR VPWR VGND sky130_fd_sc_hd__nor4b_2
Xsky130_fd_sc_hd__nand2_2_14 sky130_fd_sc_hd__or4_2_1/D I sky130_fd_sc_hd__inv_2_7/A
+ VGND VPWR VPWR VGND sky130_fd_sc_hd__nand2_2
Xsky130_fd_sc_hd__nand2_2_25 sky130_fd_sc_hd__mux2_1_7/A0 sky130_fd_sc_hd__or2_2_7/A
+ I VGND VPWR sky130_fd_sc_hd__nand2_2_25/VPB VGND sky130_fd_sc_hd__nand2_2
Xsky130_fd_sc_hd__decap_3_131 VPWR VGND sky130_fd_sc_hd__decap_3_131/VPB VGND sky130_fd_sc_hd__decap_3
Xsky130_fd_sc_hd__decap_3_120 VPWR VGND sky130_fd_sc_hd__decap_3_122/VPB VGND sky130_fd_sc_hd__decap_3
Xsky130_fd_sc_hd__decap_3_142 VPWR VGND sky130_fd_sc_hd__decap_3_144/VPB VGND sky130_fd_sc_hd__decap_3
Xsky130_fd_sc_hd__diode_2_6 sky130_fd_sc_hd__and3_2_6/X VGND VPWR VPWR VGND sky130_fd_sc_hd__diode_2
Xsky130_fd_sc_hd__decap_3_186 VPWR VGND sky130_fd_sc_hd__decap_3_200/VPB VGND sky130_fd_sc_hd__decap_3
Xsky130_fd_sc_hd__decap_3_175 VPWR VGND sky130_fd_sc_hd__decap_3_175/VPB VGND sky130_fd_sc_hd__decap_3
Xsky130_fd_sc_hd__decap_3_164 VPWR VGND sky130_fd_sc_hd__decap_3_164/VPB VGND sky130_fd_sc_hd__decap_3
Xsky130_fd_sc_hd__decap_3_153 VPWR VGND sky130_fd_sc_hd__decap_3_153/VPB VGND sky130_fd_sc_hd__decap_3
Xsky130_fd_sc_hd__decap_3_197 VPWR VGND sky130_fd_sc_hd__decap_3_197/VPB VGND sky130_fd_sc_hd__decap_3
Xsky130_fd_sc_hd__a22o_2_7 sky130_fd_sc_hd__a22o_2_7/A1 sky130_fd_sc_hd__nor3b_2_2/Y
+ sky130_fd_sc_hd__a22o_2_7/X sky130_fd_sc_hd__o21a_2_15/X sky130_fd_sc_hd__nor3_2_3/Y
+ VPWR VGND VPWR VGND sky130_fd_sc_hd__a22o_2
Xsky130_fd_sc_hd__nand4_2_3 sky130_fd_sc_hd__inv_2_7/A I sky130_fd_sc_hd__o21a_2_5/A2
+ sky130_fd_sc_hd__nand4_2_3/D sky130_fd_sc_hd__nand4_2_3/C VGND VPWR VPWR VGND sky130_fd_sc_hd__nand4_2
Xsky130_fd_sc_hd__a21o_2_12 sky130_fd_sc_hd__o32a_2_3/A3 sky130_fd_sc_hd__nor2_2_39/Y
+ sky130_fd_sc_hd__inv_2_7/A sky130_fd_sc_hd__xor2_2_19/B VGND VPWR VPWR VGND sky130_fd_sc_hd__a21o_2
Xsky130_fd_sc_hd__or3_2_8 sky130_fd_sc_hd__or3_2_8/A sky130_fd_sc_hd__or3_2_8/B sky130_fd_sc_hd__or3_2_8/X
+ sky130_fd_sc_hd__or3_2_8/C VGND VPWR VPWR VGND sky130_fd_sc_hd__or3_2
Xsky130_fd_sc_hd__and3b_2_3 sky130_fd_sc_hd__nor2_2_40/A sky130_fd_sc_hd__o32a_2_3/A2
+ sky130_fd_sc_hd__inv_2_7/A sky130_fd_sc_hd__xor2_2_16/X VGND VPWR VPWR VGND sky130_fd_sc_hd__and3b_2
Xsky130_fd_sc_hd__nor2_2_3 sky130_fd_sc_hd__nor2_2_3/B sky130_fd_sc_hd__nor2_2_3/Y
+ sky130_fd_sc_hd__or3_2_3/B VGND VPWR VPWR VGND sky130_fd_sc_hd__nor2_2
Xsky130_fd_sc_hd__mux2_1_18 sky130_fd_sc_hd__inv_2_7/A sky130_fd_sc_hd__a22o_2_2/A2
+ sky130_fd_sc_hd__mux2_1_19/A1 sky130_fd_sc_hd__mux2_1_18/X VGND VPWR VPWR VGND sky130_fd_sc_hd__mux2_1
Xsky130_fd_sc_hd__nand2b_2_22 sky130_fd_sc_hd__or2_2_10/A sky130_fd_sc_hd__nor2_2_46/A
+ sky130_fd_sc_hd__inv_2_7/A VGND VPWR VPWR VGND sky130_fd_sc_hd__nand2b_2
Xsky130_fd_sc_hd__nand2b_2_11 sky130_fd_sc_hd__or3b_2_0/A sky130_fd_sc_hd__nand2_2_31/A
+ sky130_fd_sc_hd__or2_2_9/A VGND VPWR VPWR VGND sky130_fd_sc_hd__nand2b_2
Xsky130_fd_sc_hd__o31a_2_5 sky130_fd_sc_hd__o31a_2_5/X sky130_fd_sc_hd__o31a_2_9/A1
+ sky130_fd_sc_hd__o31a_2_5/A2 sky130_fd_sc_hd__or3_2_17/X sky130_fd_sc_hd__a22o_2_8/X
+ VGND VPWR VPWR VGND sky130_fd_sc_hd__o31a_2
Xsky130_fd_sc_hd__conb_1_0 sky130_fd_sc_hd__conb_1_0/LO sky130_fd_sc_hd__conb_1_0/HI
+ VGND VPWR sky130_fd_sc_hd__o31a_2_0/VPB VGND sky130_fd_sc_hd__conb_1
Xsky130_fd_sc_hd__nor2_2_10 sky130_fd_sc_hd__or3_2_2/B sky130_fd_sc_hd__nor2_2_3/B
+ sky130_fd_sc_hd__or3_2_0/B VGND VPWR VPWR VGND sky130_fd_sc_hd__nor2_2
Xsky130_fd_sc_hd__nor2_2_21 sky130_fd_sc_hd__and3_2_4/X sky130_fd_sc_hd__xor2_2_8/B
+ sky130_fd_sc_hd__nor2_2_21/A VGND VPWR VPWR VGND sky130_fd_sc_hd__nor2_2
Xsky130_fd_sc_hd__nor2_2_32 sky130_fd_sc_hd__nor2_2_32/B sky130_fd_sc_hd__nor2_2_32/Y
+ sky130_fd_sc_hd__or2_2_8/B VGND VPWR VPWR VGND sky130_fd_sc_hd__nor2_2
Xsky130_fd_sc_hd__nor2_2_43 sky130_fd_sc_hd__or4_2_7/D sky130_fd_sc_hd__nor2_2_43/Y
+ sky130_fd_sc_hd__or4_2_7/C VGND VPWR VPWR VGND sky130_fd_sc_hd__nor2_2
Xsky130_fd_sc_hd__decap_3_80 VPWR VGND sky130_fd_sc_hd__decap_3_86/VPB VGND sky130_fd_sc_hd__decap_3
Xsky130_fd_sc_hd__decap_3_91 VPWR VGND sky130_fd_sc_hd__decap_3_91/VPB VGND sky130_fd_sc_hd__decap_3
Xsky130_fd_sc_hd__and2_2_2 sky130_fd_sc_hd__and2_2_2/A sky130_fd_sc_hd__and2_2_2/X
+ sky130_fd_sc_hd__and3_2_1/C VPWR VGND VPWR VGND sky130_fd_sc_hd__and2_2
Xsky130_fd_sc_hd__dfrtp_2_5 sky130_fd_sc_hd__nand4_2_2/C rst_n sky130_fd_sc_hd__o21a_2_8/X
+ sky130_fd_sc_hd__clkbuf_8_1/X VGND VPWR sky130_fd_sc_hd__dfrtp_2_5/VPB VGND sky130_fd_sc_hd__dfrtp_2
Xsky130_fd_sc_hd__o21a_2_4 sky130_fd_sc_hd__o21a_2_4/A1 sky130_fd_sc_hd__a31o_2_1/X
+ sky130_fd_sc_hd__o21a_2_4/A2 sky130_fd_sc_hd__o21a_2_4/X VGND VPWR VPWR VGND sky130_fd_sc_hd__o21a_2
Xsky130_fd_sc_hd__xnor2_2_3 sky130_fd_sc_hd__and3_2_2/C sky130_fd_sc_hd__xor2_2_0/B
+ sky130_fd_sc_hd__xor2_2_4/A VGND VPWR VPWR VGND sky130_fd_sc_hd__xnor2_2
Xsky130_fd_sc_hd__a22o_2_14 sky130_fd_sc_hd__and3_2_17/X sky130_fd_sc_hd__nor3b_2_2/Y
+ sky130_fd_sc_hd__o31a_2_8/A2 sky130_fd_sc_hd__and3b_2_2/X sky130_fd_sc_hd__nor3_2_3/Y
+ VPWR VGND VPWR VGND sky130_fd_sc_hd__a22o_2
Xsky130_fd_sc_hd__nand2_2_26 sky130_fd_sc_hd__o21a_2_12/A1 sky130_fd_sc_hd__and4_2_3/C
+ sky130_fd_sc_hd__nor3_2_2/A VGND VPWR VPWR VGND sky130_fd_sc_hd__nand2_2
Xsky130_fd_sc_hd__nand2_2_15 sky130_fd_sc_hd__or4_2_2/D I sky130_fd_sc_hd__inv_2_7/A
+ VGND VPWR VPWR VGND sky130_fd_sc_hd__nand2_2
Xsky130_fd_sc_hd__nand2_2_37 sky130_fd_sc_hd__or4_2_8/D I sky130_fd_sc_hd__inv_2_7/A
+ VGND VPWR VPWR VGND sky130_fd_sc_hd__nand2_2
Xsky130_fd_sc_hd__decap_3_110 VPWR VGND sky130_fd_sc_hd__decap_3_116/VPB VGND sky130_fd_sc_hd__decap_3
Xsky130_fd_sc_hd__decap_3_132 VPWR VGND sky130_fd_sc_hd__decap_3_132/VPB VGND sky130_fd_sc_hd__decap_3
Xsky130_fd_sc_hd__decap_3_121 VPWR VGND sky130_fd_sc_hd__decap_3_121/VPB VGND sky130_fd_sc_hd__decap_3
Xsky130_fd_sc_hd__decap_3_143 VPWR VGND sky130_fd_sc_hd__decap_3_153/VPB VGND sky130_fd_sc_hd__decap_3
Xsky130_fd_sc_hd__decap_3_176 VPWR VGND sky130_fd_sc_hd__decap_3_176/VPB VGND sky130_fd_sc_hd__decap_3
Xsky130_fd_sc_hd__decap_3_165 VPWR VGND VPWR VGND sky130_fd_sc_hd__decap_3
Xsky130_fd_sc_hd__decap_3_154 VPWR VGND sky130_fd_sc_hd__decap_3_157/VPB VGND sky130_fd_sc_hd__decap_3
Xsky130_fd_sc_hd__diode_2_7 sky130_fd_sc_hd__and3_2_6/X VGND VPWR VPWR VGND sky130_fd_sc_hd__diode_2
Xsky130_fd_sc_hd__decap_3_198 VPWR VGND sky130_fd_sc_hd__decap_3_198/VPB VGND sky130_fd_sc_hd__decap_3
Xsky130_fd_sc_hd__decap_3_187 VPWR VGND sky130_fd_sc_hd__decap_3_187/VPB VGND sky130_fd_sc_hd__decap_3
Xsky130_fd_sc_hd__a22o_2_8 sky130_fd_sc_hd__xor2_2_12/X sky130_fd_sc_hd__or3_2_17/B
+ sky130_fd_sc_hd__a22o_2_8/X sky130_fd_sc_hd__o32ai_2_0/Y sky130_fd_sc_hd__nor3b_2_3/Y
+ VPWR VGND VPWR VGND sky130_fd_sc_hd__a22o_2
Xsky130_fd_sc_hd__nand4_2_4 sky130_fd_sc_hd__inv_2_7/A I sky130_fd_sc_hd__nand4_2_4/Y
+ sky130_fd_sc_hd__nand4_2_4/D sky130_fd_sc_hd__nand4_2_4/C VGND VPWR VPWR VGND sky130_fd_sc_hd__nand4_2
Xsky130_fd_sc_hd__a21o_2_13 sky130_fd_sc_hd__a21o_2_13/X sky130_fd_sc_hd__or4_2_5/A
+ sky130_fd_sc_hd__inv_2_16/A sky130_fd_sc_hd__nor2_2_42/Y VGND VPWR VPWR VGND sky130_fd_sc_hd__a21o_2
Xsky130_fd_sc_hd__or3_2_9 sky130_fd_sc_hd__or3_2_9/A sky130_fd_sc_hd__or3_2_9/B sky130_fd_sc_hd__or3_2_9/X
+ sky130_fd_sc_hd__or3_2_9/C VGND VPWR VPWR VGND sky130_fd_sc_hd__or3_2
Xsky130_fd_sc_hd__nor2_2_4 sky130_fd_sc_hd__or2_2_1/B sky130_fd_sc_hd__nor2_2_4/Y
+ sky130_fd_sc_hd__or2_2_1/A VGND VPWR VPWR VGND sky130_fd_sc_hd__nor2_2
Xsky130_fd_sc_hd__mux2_1_19 sky130_fd_sc_hd__inv_2_7/A sky130_fd_sc_hd__mux2_1_19/A1
+ sky130_fd_sc_hd__mux2_1_19/A0 sky130_fd_sc_hd__mux2_1_19/X VGND VPWR VPWR VGND sky130_fd_sc_hd__mux2_1
Xsky130_fd_sc_hd__nand2b_2_23 sky130_fd_sc_hd__or2_2_11/A sky130_fd_sc_hd__a32o_2_4/B2
+ sky130_fd_sc_hd__or2_2_11/B VGND VPWR VPWR VGND sky130_fd_sc_hd__nand2b_2
Xsky130_fd_sc_hd__nand2b_2_12 sky130_fd_sc_hd__or2_2_9/A sky130_fd_sc_hd__o221a_2_2/C1
+ sky130_fd_sc_hd__or3b_2_0/A VGND VPWR VPWR VGND sky130_fd_sc_hd__nand2b_2
Xsky130_fd_sc_hd__o31a_2_6 sky130_fd_sc_hd__o31a_2_6/X sky130_fd_sc_hd__o31a_2_9/A1
+ sky130_fd_sc_hd__o31a_2_6/A2 sky130_fd_sc_hd__or3_2_10/X sky130_fd_sc_hd__o31a_2_6/A3
+ VGND VPWR VPWR VGND sky130_fd_sc_hd__o31a_2
Xsky130_fd_sc_hd__conb_1_1 sky130_fd_sc_hd__or3_2_13/A sky130_fd_sc_hd__conb_1_1/HI
+ VGND VPWR sky130_fd_sc_hd__conb_1_1/VPB VGND sky130_fd_sc_hd__conb_1
Xsky130_fd_sc_hd__nor2_2_11 sky130_fd_sc_hd__or2_2_4/B sky130_fd_sc_hd__or3_2_1/C
+ sky130_fd_sc_hd__or3_2_3/B VGND VPWR VPWR VGND sky130_fd_sc_hd__nor2_2
Xsky130_fd_sc_hd__nor2_2_22 sky130_fd_sc_hd__or2_2_9/A sky130_fd_sc_hd__nor3_2_1/B
+ sky130_fd_sc_hd__or3b_2_0/A VGND VPWR VPWR VGND sky130_fd_sc_hd__nor2_2
Xsky130_fd_sc_hd__nor2_2_44 sky130_fd_sc_hd__or4_2_8/D sky130_fd_sc_hd__nor2_2_44/Y
+ sky130_fd_sc_hd__or4_2_8/C VGND VPWR VPWR VGND sky130_fd_sc_hd__nor2_2
Xsky130_fd_sc_hd__nor2_2_33 sky130_fd_sc_hd__or2_2_9/A sky130_fd_sc_hd__nor2_2_33/Y
+ sky130_fd_sc_hd__or3b_2_0/A VGND VPWR VPWR VGND sky130_fd_sc_hd__nor2_2
Xsky130_fd_sc_hd__decap_3_70 VPWR VGND sky130_fd_sc_hd__decap_3_71/VPB VGND sky130_fd_sc_hd__decap_3
Xsky130_fd_sc_hd__decap_3_81 VPWR VGND sky130_fd_sc_hd__decap_3_85/VPB VGND sky130_fd_sc_hd__decap_3
Xsky130_fd_sc_hd__decap_3_92 VPWR VGND sky130_fd_sc_hd__decap_3_92/VPB VGND sky130_fd_sc_hd__decap_3
Xsky130_fd_sc_hd__o211a_2_10 sky130_fd_sc_hd__or2_2_9/A sky130_fd_sc_hd__inv_2_14/Y
+ sky130_fd_sc_hd__or2_2_9/B sky130_fd_sc_hd__inv_2_15/Y sky130_fd_sc_hd__o211a_2_10/X
+ VPWR VGND VPWR VGND sky130_fd_sc_hd__o211a_2
Xsky130_fd_sc_hd__and2_2_3 sky130_fd_sc_hd__or4_2_1/A sky130_fd_sc_hd__and4_2_0/A
+ sky130_fd_sc_hd__or4_2_1/B VPWR VGND VPWR VGND sky130_fd_sc_hd__and2_2
Xsky130_fd_sc_hd__dfrtp_2_6 sky130_fd_sc_hd__nand4_2_1/C rst_n sky130_fd_sc_hd__o21a_2_10/X
+ sky130_fd_sc_hd__clkbuf_8_1/X VGND VPWR VPWR VGND sky130_fd_sc_hd__dfrtp_2
Xsky130_fd_sc_hd__o21a_2_5 sky130_fd_sc_hd__o21a_2_5/A1 sky130_fd_sc_hd__a31o_2_4/X
+ sky130_fd_sc_hd__o21a_2_5/A2 sky130_fd_sc_hd__o21a_2_5/X VGND VPWR VPWR VGND sky130_fd_sc_hd__o21a_2
Xsky130_fd_sc_hd__xnor2_2_4 sky130_fd_sc_hd__xnor2_2_5/B sky130_fd_sc_hd__xnor2_2_4/A
+ sky130_fd_sc_hd__xor2_2_4/X VGND VPWR VPWR VGND sky130_fd_sc_hd__xnor2_2
Xsky130_fd_sc_hd__a22o_2_15 sky130_fd_sc_hd__o21a_2_13/X sky130_fd_sc_hd__nor3b_2_2/Y
+ sky130_fd_sc_hd__o31a_2_6/A2 sky130_fd_sc_hd__and3b_2_1/X sky130_fd_sc_hd__nor3_2_3/Y
+ VPWR VGND VPWR VGND sky130_fd_sc_hd__a22o_2
Xsky130_fd_sc_hd__nand2_2_16 sky130_fd_sc_hd__and3_2_4/B sky130_fd_sc_hd__or4_2_4/D
+ sky130_fd_sc_hd__xnor2_2_5/B VGND VPWR VPWR VGND sky130_fd_sc_hd__nand2_2
Xsky130_fd_sc_hd__nand2_2_27 sky130_fd_sc_hd__o21a_2_15/A2 sky130_fd_sc_hd__or3b_2_0/A
+ sky130_fd_sc_hd__or2_2_8/X VGND VPWR VPWR VGND sky130_fd_sc_hd__nand2_2
Xsky130_fd_sc_hd__nand2_2_38 sky130_fd_sc_hd__nand2_2_38/Y sky130_fd_sc_hd__or2_2_12/A
+ sky130_fd_sc_hd__or2_2_12/B VGND VPWR VPWR VGND sky130_fd_sc_hd__nand2_2
Xsky130_fd_sc_hd__decap_3_100 VPWR VGND sky130_fd_sc_hd__decap_3_102/VPB VGND sky130_fd_sc_hd__decap_3
Xsky130_fd_sc_hd__decap_3_133 VPWR VGND sky130_fd_sc_hd__decap_3_135/VPB VGND sky130_fd_sc_hd__decap_3
Xsky130_fd_sc_hd__decap_3_122 VPWR VGND sky130_fd_sc_hd__decap_3_122/VPB VGND sky130_fd_sc_hd__decap_3
Xsky130_fd_sc_hd__decap_3_111 VPWR VGND sky130_fd_sc_hd__decap_3_111/VPB VGND sky130_fd_sc_hd__decap_3
Xsky130_fd_sc_hd__decap_3_177 VPWR VGND sky130_fd_sc_hd__decap_3_182/VPB VGND sky130_fd_sc_hd__decap_3
Xsky130_fd_sc_hd__decap_3_166 VPWR VGND sky130_fd_sc_hd__decap_3_166/VPB VGND sky130_fd_sc_hd__decap_3
Xsky130_fd_sc_hd__decap_3_144 VPWR VGND sky130_fd_sc_hd__decap_3_144/VPB VGND sky130_fd_sc_hd__decap_3
Xsky130_fd_sc_hd__decap_3_155 VPWR VGND sky130_fd_sc_hd__decap_3_159/VPB VGND sky130_fd_sc_hd__decap_3
Xsky130_fd_sc_hd__diode_2_8 sky130_fd_sc_hd__and3_2_6/X VGND VPWR VPWR VGND sky130_fd_sc_hd__diode_2
Xsky130_fd_sc_hd__decap_3_199 VPWR VGND sky130_fd_sc_hd__decap_3_199/VPB VGND sky130_fd_sc_hd__decap_3
Xsky130_fd_sc_hd__decap_3_188 VPWR VGND sky130_fd_sc_hd__decap_3_191/VPB VGND sky130_fd_sc_hd__decap_3
Xsky130_fd_sc_hd__a22o_2_9 sky130_fd_sc_hd__a22o_2_9/A1 sky130_fd_sc_hd__or3_2_17/B
+ sky130_fd_sc_hd__a22o_2_9/X sky130_fd_sc_hd__o22a_2_2/X sky130_fd_sc_hd__nor3b_2_3/Y
+ VPWR VGND VPWR VGND sky130_fd_sc_hd__a22o_2
Xsky130_fd_sc_hd__nand4_2_5 sky130_fd_sc_hd__inv_2_7/A I sky130_fd_sc_hd__nand4_2_5/Y
+ sky130_fd_sc_hd__nand4_2_5/D sky130_fd_sc_hd__nand4_2_5/C VGND VPWR sky130_fd_sc_hd__nand4_2_5/VPB
+ VGND sky130_fd_sc_hd__nand4_2
Xsky130_fd_sc_hd__a21o_2_14 sky130_fd_sc_hd__a21o_2_14/X sky130_fd_sc_hd__or4_2_7/A
+ sky130_fd_sc_hd__inv_2_18/A sky130_fd_sc_hd__nor2_2_43/Y VGND VPWR VPWR VGND sky130_fd_sc_hd__a21o_2
Xsky130_fd_sc_hd__nor2_2_5 sky130_fd_sc_hd__or3_2_3/B sky130_fd_sc_hd__nor2_2_5/Y
+ sky130_fd_sc_hd__nor2_2_5/A VGND VPWR VPWR VGND sky130_fd_sc_hd__nor2_2
Xsky130_fd_sc_hd__nand2b_2_13 sky130_fd_sc_hd__nand4_2_6/Y sky130_fd_sc_hd__dfrtp_2_58/D
+ sky130_fd_sc_hd__o21a_2_18/A1 VGND VPWR VPWR VGND sky130_fd_sc_hd__nand2b_2
Xsky130_fd_sc_hd__o31a_2_7 sky130_fd_sc_hd__o31a_2_7/X sky130_fd_sc_hd__o31a_2_9/A1
+ sky130_fd_sc_hd__o31a_2_7/A2 sky130_fd_sc_hd__or3_2_11/X sky130_fd_sc_hd__o31a_2_7/A3
+ VGND VPWR VPWR VGND sky130_fd_sc_hd__o31a_2
Xsky130_fd_sc_hd__conb_1_2 sky130_fd_sc_hd__conb_1_2/LO sky130_fd_sc_hd__conb_1_2/HI
+ VGND VPWR VPWR VGND sky130_fd_sc_hd__conb_1
Xsky130_fd_sc_hd__nor2_2_12 sky130_fd_sc_hd__nor2_2_3/B sky130_fd_sc_hd__or3_2_4/B
+ sky130_fd_sc_hd__or2_2_4/A VGND VPWR VPWR VGND sky130_fd_sc_hd__nor2_2
Xsky130_fd_sc_hd__nor2_2_23 sky130_fd_sc_hd__and2_2_8/A sky130_fd_sc_hd__nor2_2_23/Y
+ sky130_fd_sc_hd__or2_2_8/B VGND VPWR sky130_fd_sc_hd__o22a_2_2/VPB VGND sky130_fd_sc_hd__nor2_2
Xsky130_fd_sc_hd__nor2_2_45 sky130_fd_sc_hd__or4_2_6/D sky130_fd_sc_hd__nor2_2_45/Y
+ sky130_fd_sc_hd__or4_2_6/C VGND VPWR VPWR VGND sky130_fd_sc_hd__nor2_2
Xsky130_fd_sc_hd__nor2_2_34 sky130_fd_sc_hd__nor2_2_40/A sky130_fd_sc_hd__nor2_2_34/Y
+ sky130_fd_sc_hd__inv_2_7/A VGND VPWR sky130_fd_sc_hd__nor2_2_34/VPB VGND sky130_fd_sc_hd__nor2_2
Xsky130_fd_sc_hd__decap_3_60 VPWR VGND sky130_fd_sc_hd__decap_3_67/VPB VGND sky130_fd_sc_hd__decap_3
Xsky130_fd_sc_hd__decap_3_71 VPWR VGND sky130_fd_sc_hd__decap_3_71/VPB VGND sky130_fd_sc_hd__decap_3
Xsky130_fd_sc_hd__decap_3_93 VPWR VGND sky130_fd_sc_hd__decap_3_93/VPB VGND sky130_fd_sc_hd__decap_3
Xsky130_fd_sc_hd__decap_3_82 VPWR VGND sky130_fd_sc_hd__decap_3_87/VPB VGND sky130_fd_sc_hd__decap_3
Xsky130_fd_sc_hd__o211a_2_11 sky130_fd_sc_hd__or2_2_11/B sky130_fd_sc_hd__a21o_2_17/X
+ sky130_fd_sc_hd__nand3_2_1/Y sky130_fd_sc_hd__or2_2_8/B sky130_fd_sc_hd__dfxtp_2_3/D
+ VPWR VGND VPWR VGND sky130_fd_sc_hd__o211a_2
Xsky130_fd_sc_hd__and2_2_4 sky130_fd_sc_hd__or4_2_2/A sky130_fd_sc_hd__and4_2_1/B
+ sky130_fd_sc_hd__or4_2_2/B VPWR VGND VPWR VGND sky130_fd_sc_hd__and2_2
Xsky130_fd_sc_hd__dfrtp_2_7 sky130_fd_sc_hd__inv_2_2/A rst_n sky130_fd_sc_hd__o21a_2_9/X
+ sky130_fd_sc_hd__clkbuf_8_1/X VGND VPWR VPWR VGND sky130_fd_sc_hd__dfrtp_2
Xsky130_fd_sc_hd__o21a_2_6 sky130_fd_sc_hd__inv_2_3/A sky130_fd_sc_hd__or4_2_3/X sky130_fd_sc_hd__o21a_2_6/A2
+ sky130_fd_sc_hd__o21a_2_6/X VGND VPWR VPWR VGND sky130_fd_sc_hd__o21a_2
Xsky130_fd_sc_hd__xnor2_2_5 sky130_fd_sc_hd__xnor2_2_8/A sky130_fd_sc_hd__or4_2_4/D
+ sky130_fd_sc_hd__xnor2_2_5/B VGND VPWR VPWR VGND sky130_fd_sc_hd__xnor2_2
Xsky130_fd_sc_hd__o22ai_2_0 sky130_fd_sc_hd__a31o_2_7/X sky130_fd_sc_hd__a21oi_2_5/Y
+ sky130_fd_sc_hd__o22ai_2_0/Y sky130_fd_sc_hd__xor2_2_0/B sky130_fd_sc_hd__and3_2_2/B
+ VGND VPWR VPWR VGND sky130_fd_sc_hd__o22ai_2
Xsky130_fd_sc_hd__a22o_2_16 sky130_fd_sc_hd__o211a_2_10/X sky130_fd_sc_hd__nor3b_2_2/Y
+ sky130_fd_sc_hd__o31a_2_7/A2 sky130_fd_sc_hd__and2b_2_19/X sky130_fd_sc_hd__nor3_2_3/Y
+ VPWR VGND VPWR VGND sky130_fd_sc_hd__a22o_2
Xsky130_fd_sc_hd__a31o_2_0 sky130_fd_sc_hd__a31o_2_0/X sky130_fd_sc_hd__and3_2_0/C
+ sky130_fd_sc_hd__and3_2_1/C sky130_fd_sc_hd__or3_2_3/B sky130_fd_sc_hd__and2_2_2/A
+ VGND VPWR VPWR VGND sky130_fd_sc_hd__a31o_2
Xsky130_fd_sc_hd__nand2_2_17 sky130_fd_sc_hd__xnor2_2_4/A sky130_fd_sc_hd__xor2_2_0/B
+ sky130_fd_sc_hd__xor2_2_9/A VGND VPWR VPWR VGND sky130_fd_sc_hd__nand2_2
Xsky130_fd_sc_hd__nand2_2_28 sky130_fd_sc_hd__o32a_2_2/B2 sky130_fd_sc_hd__or2_2_9/X
+ sky130_fd_sc_hd__o32a_2_2/A2 VGND VPWR sky130_fd_sc_hd__nor2_2_34/VPB VGND sky130_fd_sc_hd__nand2_2
Xsky130_fd_sc_hd__decap_3_101 VPWR VGND sky130_fd_sc_hd__decap_3_97/VPB VGND sky130_fd_sc_hd__decap_3
Xsky130_fd_sc_hd__decap_3_134 VPWR VGND sky130_fd_sc_hd__decap_3_137/VPB VGND sky130_fd_sc_hd__decap_3
Xsky130_fd_sc_hd__decap_3_123 VPWR VGND sky130_fd_sc_hd__decap_3_136/VPB VGND sky130_fd_sc_hd__decap_3
Xsky130_fd_sc_hd__decap_3_112 VPWR VGND sky130_fd_sc_hd__decap_3_114/VPB VGND sky130_fd_sc_hd__decap_3
Xsky130_fd_sc_hd__decap_3_167 VPWR VGND VPWR VGND sky130_fd_sc_hd__decap_3
Xsky130_fd_sc_hd__decap_3_145 VPWR VGND sky130_fd_sc_hd__decap_3_145/VPB VGND sky130_fd_sc_hd__decap_3
Xsky130_fd_sc_hd__decap_3_156 VPWR VGND sky130_fd_sc_hd__decap_3_158/VPB VGND sky130_fd_sc_hd__decap_3
Xsky130_fd_sc_hd__diode_2_9 sky130_fd_sc_hd__and4_2_3/X VGND VPWR sky130_fd_sc_hd__diode_2_9/VPB
+ VGND sky130_fd_sc_hd__diode_2
Xsky130_fd_sc_hd__decap_3_189 VPWR VGND sky130_fd_sc_hd__decap_3_190/VPB VGND sky130_fd_sc_hd__decap_3
Xsky130_fd_sc_hd__decap_3_178 VPWR VGND sky130_fd_sc_hd__decap_3_181/VPB VGND sky130_fd_sc_hd__decap_3
Xsky130_fd_sc_hd__nand4_2_6 sky130_fd_sc_hd__inv_2_7/A I sky130_fd_sc_hd__nand4_2_6/Y
+ sky130_fd_sc_hd__nand4_2_6/D sky130_fd_sc_hd__nand4_2_6/C VGND VPWR VPWR VGND sky130_fd_sc_hd__nand4_2
Xsky130_fd_sc_hd__a21o_2_15 sky130_fd_sc_hd__a21o_2_15/X sky130_fd_sc_hd__or4_2_8/A
+ sky130_fd_sc_hd__inv_2_19/A sky130_fd_sc_hd__nor2_2_44/Y VGND VPWR VPWR VGND sky130_fd_sc_hd__a21o_2
Xsky130_fd_sc_hd__or2_2_0 sky130_fd_sc_hd__or2_2_0/B sky130_fd_sc_hd__or2_2_4/B sky130_fd_sc_hd__or2_2_2/A
+ VPWR VGND VPWR VGND sky130_fd_sc_hd__or2_2
Xsky130_fd_sc_hd__nor2_2_6 sky130_fd_sc_hd__xor2_2_9/A sky130_fd_sc_hd__nor2_2_6/Y
+ sky130_fd_sc_hd__xor2_2_0/B VGND VPWR VPWR VGND sky130_fd_sc_hd__nor2_2
Xsky130_fd_sc_hd__nand2b_2_14 sky130_fd_sc_hd__nand4_2_7/Y sky130_fd_sc_hd__dfrtp_2_57/D
+ sky130_fd_sc_hd__o21a_2_19/A1 VGND VPWR VPWR VGND sky130_fd_sc_hd__nand2b_2
Xsky130_fd_sc_hd__o31a_2_8 sky130_fd_sc_hd__o31a_2_8/X sky130_fd_sc_hd__o31a_2_9/A1
+ sky130_fd_sc_hd__o31a_2_8/A2 sky130_fd_sc_hd__or3_2_14/X sky130_fd_sc_hd__o31a_2_8/A3
+ VGND VPWR VPWR VGND sky130_fd_sc_hd__o31a_2
Xsky130_fd_sc_hd__conb_1_3 sky130_fd_sc_hd__conb_1_3/LO sky130_fd_sc_hd__conb_1_3/HI
+ VGND VPWR VPWR VGND sky130_fd_sc_hd__conb_1
Xsky130_fd_sc_hd__nor2_2_13 sky130_fd_sc_hd__or3_2_0/X sky130_fd_sc_hd__o32a_2_1/A3
+ sky130_fd_sc_hd__or2_2_4/A VGND VPWR VPWR VGND sky130_fd_sc_hd__nor2_2
Xsky130_fd_sc_hd__nor2_2_46 sky130_fd_sc_hd__nor2_2_46/B sky130_fd_sc_hd__nor2_2_46/Y
+ sky130_fd_sc_hd__nor2_2_46/A VGND VPWR VPWR VGND sky130_fd_sc_hd__nor2_2
Xsky130_fd_sc_hd__nor2_2_24 sky130_fd_sc_hd__or2_2_8/B sky130_fd_sc_hd__nor2_2_24/Y
+ sky130_fd_sc_hd__or2_2_9/A VGND VPWR sky130_fd_sc_hd__a21o_2_7/VPB VGND sky130_fd_sc_hd__nor2_2
Xsky130_fd_sc_hd__nor2_2_35 sky130_fd_sc_hd__o32a_2_2/B1 sky130_fd_sc_hd__o32a_2_2/A3
+ sky130_fd_sc_hd__or2_2_9/B VGND VPWR VPWR VGND sky130_fd_sc_hd__nor2_2
Xsky130_fd_sc_hd__decap_3_50 VPWR VGND sky130_fd_sc_hd__decap_3_53/VPB VGND sky130_fd_sc_hd__decap_3
Xsky130_fd_sc_hd__decap_3_72 VPWR VGND sky130_fd_sc_hd__decap_3_74/VPB VGND sky130_fd_sc_hd__decap_3
Xsky130_fd_sc_hd__decap_3_61 VPWR VGND sky130_fd_sc_hd__decap_3_61/VPB VGND sky130_fd_sc_hd__decap_3
Xsky130_fd_sc_hd__decap_3_94 VPWR VGND sky130_fd_sc_hd__decap_3_96/VPB VGND sky130_fd_sc_hd__decap_3
Xsky130_fd_sc_hd__decap_3_83 VPWR VGND sky130_fd_sc_hd__decap_3_88/VPB VGND sky130_fd_sc_hd__decap_3
Xsky130_fd_sc_hd__a31o_2_20 sky130_fd_sc_hd__a31o_2_20/X sky130_fd_sc_hd__nand4_2_11/C
+ sky130_fd_sc_hd__and4b_2_2/X I sky130_fd_sc_hd__inv_2_7/A VGND VPWR sky130_fd_sc_hd__a31o_2_20/VPB
+ VGND sky130_fd_sc_hd__a31o_2
Xsky130_fd_sc_hd__and2_2_5 sky130_fd_sc_hd__or4_2_3/A sky130_fd_sc_hd__and4_2_0/D
+ sky130_fd_sc_hd__or4_2_3/B VPWR VGND VPWR VGND sky130_fd_sc_hd__and2_2
Xsky130_fd_sc_hd__dfrtp_2_8 sky130_fd_sc_hd__nand4_2_3/C rst_n sky130_fd_sc_hd__o21a_2_5/X
+ sky130_fd_sc_hd__dfrtp_2_8/CLK VGND VPWR VPWR VGND sky130_fd_sc_hd__dfrtp_2
Xsky130_fd_sc_hd__o21a_2_7 sky130_fd_sc_hd__inv_2_1/A sky130_fd_sc_hd__or4_2_1/X sky130_fd_sc_hd__o21a_2_7/A2
+ sky130_fd_sc_hd__o21a_2_7/X VGND VPWR VPWR VGND sky130_fd_sc_hd__o21a_2
Xsky130_fd_sc_hd__xnor2_2_6 sky130_fd_sc_hd__xnor2_2_6/Y sky130_fd_sc_hd__xnor2_2_6/A
+ sky130_fd_sc_hd__a21o_2_6/X VGND VPWR VPWR VGND sky130_fd_sc_hd__xnor2_2
Xsky130_fd_sc_hd__o22ai_2_1 sky130_fd_sc_hd__or2_2_5/A sky130_fd_sc_hd__or3_2_3/X
+ sky130_fd_sc_hd__o22ai_2_1/Y sky130_fd_sc_hd__or2_2_4/A sky130_fd_sc_hd__nand2_2_5/Y
+ VGND VPWR VPWR VGND sky130_fd_sc_hd__o22ai_2
Xsky130_fd_sc_hd__a22o_2_17 sky130_fd_sc_hd__xor2_2_18/X sky130_fd_sc_hd__or3_2_17/B
+ sky130_fd_sc_hd__a22o_2_17/X sky130_fd_sc_hd__xnor2_2_6/Y sky130_fd_sc_hd__nor3b_2_3/Y
+ VPWR VGND VPWR VGND sky130_fd_sc_hd__a22o_2
Xsky130_fd_sc_hd__a31o_2_1 sky130_fd_sc_hd__a31o_2_1/X sky130_fd_sc_hd__nand4_2_0/C
+ sky130_fd_sc_hd__nor4_2_0/Y I sky130_fd_sc_hd__inv_2_7/A VGND VPWR sky130_fd_sc_hd__nor4_2_0/VPB
+ VGND sky130_fd_sc_hd__a31o_2
Xsky130_fd_sc_hd__nand2_2_18 sky130_fd_sc_hd__a21o_2_8/A2 sky130_fd_sc_hd__xnor2_2_8/A
+ sky130_fd_sc_hd__xnor2_2_8/B VGND VPWR VPWR VGND sky130_fd_sc_hd__nand2_2
Xsky130_fd_sc_hd__nand2_2_29 sky130_fd_sc_hd__nand2_2_29/Y sky130_fd_sc_hd__or3b_2_0/A
+ sky130_fd_sc_hd__or2_2_9/A VGND VPWR sky130_fd_sc_hd__nor2_2_34/VPB VGND sky130_fd_sc_hd__nand2_2
Xsky130_fd_sc_hd__decap_3_124 VPWR VGND sky130_fd_sc_hd__decap_3_125/VPB VGND sky130_fd_sc_hd__decap_3
Xsky130_fd_sc_hd__decap_3_113 VPWR VGND sky130_fd_sc_hd__decap_3_119/VPB VGND sky130_fd_sc_hd__decap_3
Xsky130_fd_sc_hd__decap_3_102 VPWR VGND sky130_fd_sc_hd__decap_3_102/VPB VGND sky130_fd_sc_hd__decap_3
Xsky130_fd_sc_hd__decap_3_135 VPWR VGND sky130_fd_sc_hd__decap_3_135/VPB VGND sky130_fd_sc_hd__decap_3
Xsky130_fd_sc_hd__decap_3_146 VPWR VGND sky130_fd_sc_hd__decap_3_146/VPB VGND sky130_fd_sc_hd__decap_3
Xsky130_fd_sc_hd__decap_3_168 VPWR VGND sky130_fd_sc_hd__decap_3_169/VPB VGND sky130_fd_sc_hd__decap_3
Xsky130_fd_sc_hd__decap_3_157 VPWR VGND sky130_fd_sc_hd__decap_3_157/VPB VGND sky130_fd_sc_hd__decap_3
Xsky130_fd_sc_hd__decap_3_179 VPWR VGND sky130_fd_sc_hd__decap_3_180/VPB VGND sky130_fd_sc_hd__decap_3
Xsky130_fd_sc_hd__o21ai_2_0 sky130_fd_sc_hd__or4_2_0/A sky130_fd_sc_hd__and3_2_3/C
+ sky130_fd_sc_hd__and3_2_1/X sky130_fd_sc_hd__or3_2_4/B VGND VPWR VPWR VGND sky130_fd_sc_hd__o21ai_2
Xsky130_fd_sc_hd__nand4_2_7 sky130_fd_sc_hd__inv_2_7/A I sky130_fd_sc_hd__nand4_2_7/Y
+ sky130_fd_sc_hd__nor4_2_1/Y sky130_fd_sc_hd__nand4_2_7/C VGND VPWR sky130_fd_sc_hd__nor4_2_1/VPB
+ VGND sky130_fd_sc_hd__nand4_2
Xsky130_fd_sc_hd__a21o_2_16 sky130_fd_sc_hd__a21o_2_16/X sky130_fd_sc_hd__or4_2_6/A
+ sky130_fd_sc_hd__inv_2_20/A sky130_fd_sc_hd__nor2_2_45/Y VGND VPWR VPWR VGND sky130_fd_sc_hd__a21o_2
Xsky130_fd_sc_hd__a21o_2_0 sky130_fd_sc_hd__a21o_2_0/X sky130_fd_sc_hd__or4_2_1/A
+ sky130_fd_sc_hd__inv_2_1/A sky130_fd_sc_hd__o21a_2_7/A2 VGND VPWR VPWR VGND sky130_fd_sc_hd__a21o_2
Xsky130_fd_sc_hd__or2_2_1 sky130_fd_sc_hd__or2_2_1/B sky130_fd_sc_hd__or2_2_1/X sky130_fd_sc_hd__or2_2_1/A
+ VPWR VGND VPWR VGND sky130_fd_sc_hd__or2_2
Xsky130_fd_sc_hd__nor2_2_7 sky130_fd_sc_hd__xor2_2_7/A sky130_fd_sc_hd__or2_2_1/B
+ sky130_fd_sc_hd__or4_2_4/A VGND VPWR VPWR VGND sky130_fd_sc_hd__nor2_2
Xsky130_fd_sc_hd__nand2b_2_15 sky130_fd_sc_hd__nand4_2_4/Y sky130_fd_sc_hd__dfrtp_2_59/D
+ sky130_fd_sc_hd__o21a_2_16/A1 VGND VPWR VPWR VGND sky130_fd_sc_hd__nand2b_2
Xsky130_fd_sc_hd__o31a_2_9 sky130_fd_sc_hd__o31a_2_9/X sky130_fd_sc_hd__o31a_2_9/A1
+ sky130_fd_sc_hd__o31a_2_9/A2 sky130_fd_sc_hd__or3_2_16/X sky130_fd_sc_hd__o31a_2_9/A3
+ VGND VPWR VPWR VGND sky130_fd_sc_hd__o31a_2
Xsky130_fd_sc_hd__conb_1_4 sky130_fd_sc_hd__conb_1_4/LO sky130_fd_sc_hd__conb_1_4/HI
+ VGND VPWR sky130_fd_sc_hd__o31a_2_2/VPB VGND sky130_fd_sc_hd__conb_1
Xsky130_fd_sc_hd__nor2_2_14 sky130_fd_sc_hd__or4_2_3/D sky130_fd_sc_hd__o21a_2_6/A2
+ sky130_fd_sc_hd__or4_2_3/C VGND VPWR VPWR VGND sky130_fd_sc_hd__nor2_2
Xsky130_fd_sc_hd__nor2_2_47 sky130_fd_sc_hd__or3_2_17/C sky130_fd_sc_hd__o31a_2_9/A1
+ sky130_fd_sc_hd__or3_2_17/B VGND VPWR VPWR VGND sky130_fd_sc_hd__nor2_2
Xsky130_fd_sc_hd__nor2_2_25 sky130_fd_sc_hd__and3_2_2/B sky130_fd_sc_hd__or3_2_5/A
+ sky130_fd_sc_hd__xor2_2_0/B VGND VPWR VPWR VGND sky130_fd_sc_hd__nor2_2
Xsky130_fd_sc_hd__nor2_2_36 sky130_fd_sc_hd__inv_2_13/Y sky130_fd_sc_hd__or3_2_9/A
+ sky130_fd_sc_hd__or3b_2_0/A VGND VPWR VPWR VGND sky130_fd_sc_hd__nor2_2
Xsky130_fd_sc_hd__decap_3_51 VPWR VGND sky130_fd_sc_hd__decap_3_51/VPB VGND sky130_fd_sc_hd__decap_3
Xsky130_fd_sc_hd__decap_3_40 VPWR VGND sky130_fd_sc_hd__decap_3_45/VPB VGND sky130_fd_sc_hd__decap_3
Xsky130_fd_sc_hd__decap_3_62 VPWR VGND sky130_fd_sc_hd__decap_3_73/VPB VGND sky130_fd_sc_hd__decap_3
Xsky130_fd_sc_hd__decap_3_73 VPWR VGND sky130_fd_sc_hd__decap_3_73/VPB VGND sky130_fd_sc_hd__decap_3
Xsky130_fd_sc_hd__decap_3_84 VPWR VGND sky130_fd_sc_hd__decap_3_84/VPB VGND sky130_fd_sc_hd__decap_3
Xsky130_fd_sc_hd__decap_3_95 VPWR VGND sky130_fd_sc_hd__decap_3_98/VPB VGND sky130_fd_sc_hd__decap_3
Xsky130_fd_sc_hd__a31o_2_21 sky130_fd_sc_hd__a31o_2_21/X sky130_fd_sc_hd__nand4_2_13/C
+ sky130_fd_sc_hd__nand4_2_13/D I sky130_fd_sc_hd__inv_2_7/A VGND VPWR VPWR VGND sky130_fd_sc_hd__a31o_2
Xsky130_fd_sc_hd__a31o_2_10 sky130_fd_sc_hd__and2b_2_9/B sky130_fd_sc_hd__nor3_2_2/B
+ sky130_fd_sc_hd__and4_2_4/D sky130_fd_sc_hd__and4_2_4/B sky130_fd_sc_hd__inv_2_10/A
+ VGND VPWR VPWR VGND sky130_fd_sc_hd__a31o_2
Xsky130_fd_sc_hd__and2_2_6 sky130_fd_sc_hd__or3b_2_0/A sky130_fd_sc_hd__nor3_2_1/C
+ sky130_fd_sc_hd__or2_2_9/A VPWR VGND sky130_fd_sc_hd__o31a_2_0/VPB VGND sky130_fd_sc_hd__and2_2
Xsky130_fd_sc_hd__dfrtp_2_9 sky130_fd_sc_hd__inv_2_3/A rst_n sky130_fd_sc_hd__o21a_2_6/X
+ sky130_fd_sc_hd__clkbuf_8_0/X VGND VPWR VPWR VGND sky130_fd_sc_hd__dfrtp_2
Xsky130_fd_sc_hd__o21a_2_8 sky130_fd_sc_hd__o21a_2_8/A1 sky130_fd_sc_hd__a31o_2_2/X
+ sky130_fd_sc_hd__o21a_2_8/A2 sky130_fd_sc_hd__o21a_2_8/X VGND VPWR VPWR VGND sky130_fd_sc_hd__o21a_2
Xsky130_fd_sc_hd__xnor2_2_7 sky130_fd_sc_hd__or3_2_7/A sky130_fd_sc_hd__xor2_2_5/A
+ sky130_fd_sc_hd__xor2_2_5/B VGND VPWR VPWR VGND sky130_fd_sc_hd__xnor2_2
Xsky130_fd_sc_hd__or3_2_10 sky130_fd_sc_hd__or3_2_10/A sky130_fd_sc_hd__or3_2_17/B
+ sky130_fd_sc_hd__or3_2_10/X sky130_fd_sc_hd__or3_2_17/C VGND VPWR VPWR VGND sky130_fd_sc_hd__or3_2
Xsky130_fd_sc_hd__a22o_2_18 sky130_fd_sc_hd__xnor2_2_22/Y sky130_fd_sc_hd__or3_2_17/B
+ sky130_fd_sc_hd__o31a_2_7/A3 sky130_fd_sc_hd__and2_2_8/X sky130_fd_sc_hd__nor3b_2_3/Y
+ VPWR VGND VPWR VGND sky130_fd_sc_hd__a22o_2
Xsky130_fd_sc_hd__a31o_2_2 sky130_fd_sc_hd__a31o_2_2/X sky130_fd_sc_hd__nand4_2_2/C
+ sky130_fd_sc_hd__nand4_2_2/D I sky130_fd_sc_hd__inv_2_7/A VGND VPWR VPWR VGND sky130_fd_sc_hd__a31o_2
Xsky130_fd_sc_hd__nand2_2_19 sky130_fd_sc_hd__and2_2_8/A sky130_fd_sc_hd__or3b_2_0/A
+ sky130_fd_sc_hd__or2_2_9/A VGND VPWR VPWR VGND sky130_fd_sc_hd__nand2_2
Xsky130_fd_sc_hd__and4bb_2_0 sky130_fd_sc_hd__xor2_2_7/A sky130_fd_sc_hd__xor2_2_9/A
+ sky130_fd_sc_hd__xor2_2_0/B sky130_fd_sc_hd__and4bb_2_0/X sky130_fd_sc_hd__xor2_2_4/A
+ VGND VPWR VPWR VGND sky130_fd_sc_hd__and4bb_2
Xsky130_fd_sc_hd__decap_3_125 VPWR VGND sky130_fd_sc_hd__decap_3_125/VPB VGND sky130_fd_sc_hd__decap_3
Xsky130_fd_sc_hd__decap_3_114 VPWR VGND sky130_fd_sc_hd__decap_3_114/VPB VGND sky130_fd_sc_hd__decap_3
Xsky130_fd_sc_hd__decap_3_103 VPWR VGND sky130_fd_sc_hd__decap_3_99/VPB VGND sky130_fd_sc_hd__decap_3
Xsky130_fd_sc_hd__decap_3_136 VPWR VGND sky130_fd_sc_hd__decap_3_136/VPB VGND sky130_fd_sc_hd__decap_3
Xsky130_fd_sc_hd__decap_3_147 VPWR VGND sky130_fd_sc_hd__decap_3_149/VPB VGND sky130_fd_sc_hd__decap_3
Xsky130_fd_sc_hd__decap_3_158 VPWR VGND sky130_fd_sc_hd__decap_3_158/VPB VGND sky130_fd_sc_hd__decap_3
Xsky130_fd_sc_hd__decap_3_169 VPWR VGND sky130_fd_sc_hd__decap_3_169/VPB VGND sky130_fd_sc_hd__decap_3
Xsky130_fd_sc_hd__o21ai_2_1 sky130_fd_sc_hd__or4_2_0/X sky130_fd_sc_hd__o21ai_2_1/Y
+ sky130_fd_sc_hd__o32a_2_0/X sky130_fd_sc_hd__or2_2_5/A VGND VPWR VPWR VGND sky130_fd_sc_hd__o21ai_2
Xsky130_fd_sc_hd__nand4_2_8 sky130_fd_sc_hd__inv_2_7/A I sky130_fd_sc_hd__nand4_2_8/Y
+ sky130_fd_sc_hd__nand4_2_8/D sky130_fd_sc_hd__nand4_2_8/C VGND VPWR VPWR VGND sky130_fd_sc_hd__nand4_2
Xsky130_fd_sc_hd__a21o_2_17 sky130_fd_sc_hd__a21o_2_17/X sky130_fd_sc_hd__or2_2_9/B
+ sky130_fd_sc_hd__or2_2_9/A sky130_fd_sc_hd__or3b_2_0/A VGND VPWR sky130_fd_sc_hd__and2_2_16/VPB
+ VGND sky130_fd_sc_hd__a21o_2
Xsky130_fd_sc_hd__a21o_2_1 sky130_fd_sc_hd__a21o_2_1/X sky130_fd_sc_hd__or4_2_2/A
+ sky130_fd_sc_hd__inv_2_2/A sky130_fd_sc_hd__o21a_2_9/A2 VGND VPWR VPWR VGND sky130_fd_sc_hd__a21o_2
Xsky130_fd_sc_hd__or2_2_2 sky130_fd_sc_hd__or3_2_2/B sky130_fd_sc_hd__or3_2_3/C sky130_fd_sc_hd__or2_2_2/A
+ VPWR VGND VPWR VGND sky130_fd_sc_hd__or2_2
Xsky130_fd_sc_hd__nor2_2_8 sky130_fd_sc_hd__or2_2_1/X sky130_fd_sc_hd__or3_2_3/A sky130_fd_sc_hd__nor2_2_8/A
+ VGND VPWR VPWR VGND sky130_fd_sc_hd__nor2_2
Xsky130_fd_sc_hd__nand2b_2_16 sky130_fd_sc_hd__nand4_2_9/Y sky130_fd_sc_hd__dfrtp_2_66/D
+ sky130_fd_sc_hd__o21a_2_21/A1 VGND VPWR VPWR VGND sky130_fd_sc_hd__nand2b_2
Xsky130_fd_sc_hd__conb_1_5 sky130_fd_sc_hd__conb_1_5/LO sky130_fd_sc_hd__conb_1_5/HI
+ VGND VPWR VPWR VGND sky130_fd_sc_hd__conb_1
Xsky130_fd_sc_hd__nor2_2_37 sky130_fd_sc_hd__or2_2_8/B sky130_fd_sc_hd__or3_2_9/C
+ sky130_fd_sc_hd__or2_2_9/B VGND VPWR VPWR VGND sky130_fd_sc_hd__nor2_2
Xsky130_fd_sc_hd__nor2_2_26 sky130_fd_sc_hd__or2_2_4/A sky130_fd_sc_hd__nor2_2_26/Y
+ sky130_fd_sc_hd__nor2_2_5/A VGND VPWR VPWR VGND sky130_fd_sc_hd__nor2_2
Xsky130_fd_sc_hd__nor2_2_15 sky130_fd_sc_hd__or4_2_1/D sky130_fd_sc_hd__o21a_2_7/A2
+ sky130_fd_sc_hd__or4_2_1/C VGND VPWR VPWR VGND sky130_fd_sc_hd__nor2_2
Xsky130_fd_sc_hd__nor2_2_48 sky130_fd_sc_hd__o21ba_2_1/X sky130_fd_sc_hd__nor3_2_3/B
+ sky130_fd_sc_hd__or4b_2_8/A VGND VPWR VPWR VGND sky130_fd_sc_hd__nor2_2
Xsky130_fd_sc_hd__nand3b_2_0 sky130_fd_sc_hd__and3_2_7/C sky130_fd_sc_hd__xor2_2_0/B
+ sky130_fd_sc_hd__xor2_2_9/A sky130_fd_sc_hd__xor2_2_4/A VGND VPWR VPWR VGND sky130_fd_sc_hd__nand3b_2
Xsky130_fd_sc_hd__decap_3_30 VPWR VGND sky130_fd_sc_hd__decap_3_30/VPB VGND sky130_fd_sc_hd__decap_3
Xsky130_fd_sc_hd__decap_3_52 VPWR VGND sky130_fd_sc_hd__decap_3_76/VPB VGND sky130_fd_sc_hd__decap_3
Xsky130_fd_sc_hd__decap_3_41 VPWR VGND sky130_fd_sc_hd__decap_3_44/VPB VGND sky130_fd_sc_hd__decap_3
Xsky130_fd_sc_hd__decap_3_63 VPWR VGND sky130_fd_sc_hd__decap_3_66/VPB VGND sky130_fd_sc_hd__decap_3
Xsky130_fd_sc_hd__decap_3_96 VPWR VGND sky130_fd_sc_hd__decap_3_96/VPB VGND sky130_fd_sc_hd__decap_3
Xsky130_fd_sc_hd__decap_3_74 VPWR VGND sky130_fd_sc_hd__decap_3_74/VPB VGND sky130_fd_sc_hd__decap_3
Xsky130_fd_sc_hd__decap_3_85 VPWR VGND sky130_fd_sc_hd__decap_3_85/VPB VGND sky130_fd_sc_hd__decap_3
Xsky130_fd_sc_hd__a31o_2_22 sky130_fd_sc_hd__a31o_2_22/X sky130_fd_sc_hd__nand4_2_12/C
+ sky130_fd_sc_hd__nand4_2_12/D I sky130_fd_sc_hd__inv_2_7/A VGND VPWR VPWR VGND sky130_fd_sc_hd__a31o_2
Xsky130_fd_sc_hd__a31o_2_11 sky130_fd_sc_hd__a31o_2_11/X sky130_fd_sc_hd__inv_2_6/A
+ sky130_fd_sc_hd__mux2_1_7/X sky130_fd_sc_hd__inv_2_9/A sky130_fd_sc_hd__inv_2_7/A
+ VGND VPWR VPWR VGND sky130_fd_sc_hd__a31o_2
Xsky130_fd_sc_hd__and2_2_7 sky130_fd_sc_hd__or2_2_9/A sky130_fd_sc_hd__and2_2_7/X
+ sky130_fd_sc_hd__and2_2_7/B VPWR VGND VPWR VGND sky130_fd_sc_hd__and2_2
Xsky130_fd_sc_hd__o21a_2_9 sky130_fd_sc_hd__inv_2_2/A sky130_fd_sc_hd__or4_2_2/X sky130_fd_sc_hd__o21a_2_9/A2
+ sky130_fd_sc_hd__o21a_2_9/X VGND VPWR VPWR VGND sky130_fd_sc_hd__o21a_2
Xsky130_fd_sc_hd__xnor2_2_8 sky130_fd_sc_hd__xor2_2_2/B sky130_fd_sc_hd__xnor2_2_8/A
+ sky130_fd_sc_hd__xnor2_2_8/B VGND VPWR VPWR VGND sky130_fd_sc_hd__xnor2_2
Xsky130_fd_sc_hd__or3_2_11 sky130_fd_sc_hd__or3_2_11/A sky130_fd_sc_hd__or3_2_17/B
+ sky130_fd_sc_hd__or3_2_11/X sky130_fd_sc_hd__or3_2_17/C VGND VPWR VPWR VGND sky130_fd_sc_hd__or3_2
Xsky130_fd_sc_hd__a22o_2_19 sky130_fd_sc_hd__xor2_2_20/X sky130_fd_sc_hd__or3_2_17/B
+ sky130_fd_sc_hd__o31a_2_8/A3 sky130_fd_sc_hd__nor2_2_23/Y sky130_fd_sc_hd__nor3b_2_3/Y
+ VPWR VGND VPWR VGND sky130_fd_sc_hd__a22o_2
Xsky130_fd_sc_hd__a2111oi_2_0 sky130_fd_sc_hd__nor2_2_33/Y sky130_fd_sc_hd__and3_2_17/C
+ sky130_fd_sc_hd__or2_2_9/B sky130_fd_sc_hd__or3b_2_0/A sky130_fd_sc_hd__a22o_2_13/A1
+ sky130_fd_sc_hd__or2_2_8/B VGND VPWR VPWR VGND sky130_fd_sc_hd__a2111oi_2
Xsky130_fd_sc_hd__a31o_2_3 sky130_fd_sc_hd__a31o_2_3/X sky130_fd_sc_hd__nand4_2_1/C
+ sky130_fd_sc_hd__nand4_2_1/D I sky130_fd_sc_hd__inv_2_7/A VGND VPWR VPWR VGND sky130_fd_sc_hd__a31o_2
Xsky130_fd_sc_hd__and4bb_2_1 sky130_fd_sc_hd__or4b_2_2/C sky130_fd_sc_hd__or4b_2_3/B
+ sky130_fd_sc_hd__or4b_2_3/C sky130_fd_sc_hd__nand4_2_3/D sky130_fd_sc_hd__or4b_2_3/A
+ VGND VPWR VPWR VGND sky130_fd_sc_hd__and4bb_2
Xsky130_fd_sc_hd__decap_3_115 VPWR VGND sky130_fd_sc_hd__decap_3_139/VPB VGND sky130_fd_sc_hd__decap_3
Xsky130_fd_sc_hd__decap_3_104 VPWR VGND sky130_fd_sc_hd__decap_3_92/VPB VGND sky130_fd_sc_hd__decap_3
Xsky130_fd_sc_hd__decap_3_126 VPWR VGND sky130_fd_sc_hd__decap_3_132/VPB VGND sky130_fd_sc_hd__decap_3
Xsky130_fd_sc_hd__decap_3_137 VPWR VGND sky130_fd_sc_hd__decap_3_137/VPB VGND sky130_fd_sc_hd__decap_3
Xsky130_fd_sc_hd__decap_3_159 VPWR VGND sky130_fd_sc_hd__decap_3_159/VPB VGND sky130_fd_sc_hd__decap_3
Xsky130_fd_sc_hd__decap_3_148 VPWR VGND sky130_fd_sc_hd__decap_3_150/VPB VGND sky130_fd_sc_hd__decap_3
Xsky130_fd_sc_hd__o21ai_2_2 sky130_fd_sc_hd__or4_2_0/A sky130_fd_sc_hd__o21ai_2_2/Y
+ sky130_fd_sc_hd__inv_2_0/Y sky130_fd_sc_hd__or3_2_3/B VGND VPWR sky130_fd_sc_hd__and3_2_3/VPB
+ VGND sky130_fd_sc_hd__o21ai_2
Xsky130_fd_sc_hd__nand4_2_9 sky130_fd_sc_hd__inv_2_7/A I sky130_fd_sc_hd__nand4_2_9/Y
+ sky130_fd_sc_hd__nand4_2_9/D sky130_fd_sc_hd__nand4_2_9/C VGND VPWR VPWR VGND sky130_fd_sc_hd__nand4_2
Xsky130_fd_sc_hd__a21o_2_18 sky130_fd_sc_hd__a21o_2_18/X sky130_fd_sc_hd__or4_2_9/A
+ sky130_fd_sc_hd__inv_2_17/A sky130_fd_sc_hd__nor2_2_41/Y VGND VPWR VPWR VGND sky130_fd_sc_hd__a21o_2
Xsky130_fd_sc_hd__a21o_2_2 sky130_fd_sc_hd__a21o_2_2/X sky130_fd_sc_hd__or4_2_3/A
+ sky130_fd_sc_hd__inv_2_3/A sky130_fd_sc_hd__o21a_2_6/A2 VGND VPWR VPWR VGND sky130_fd_sc_hd__a21o_2
Xsky130_fd_sc_hd__or2_2_3 sky130_fd_sc_hd__or3_2_2/B sky130_fd_sc_hd__or2_2_3/X sky130_fd_sc_hd__or2_2_4/A
+ VPWR VGND VPWR VGND sky130_fd_sc_hd__or2_2
Xsky130_fd_sc_hd__nor2_2_9 sky130_fd_sc_hd__nor2_2_9/B sky130_fd_sc_hd__inv_2_4/A
+ sky130_fd_sc_hd__or2_2_1/B VGND VPWR VPWR VGND sky130_fd_sc_hd__nor2_2
Xsky130_fd_sc_hd__nand2b_2_17 sky130_fd_sc_hd__nand4_2_8/Y sky130_fd_sc_hd__dfrtp_2_63/D
+ sky130_fd_sc_hd__o21a_2_23/A1 VGND VPWR VPWR VGND sky130_fd_sc_hd__nand2b_2
Xsky130_fd_sc_hd__nor2_2_38 sky130_fd_sc_hd__or2_2_9/A sky130_fd_sc_hd__or3_2_9/B
+ sky130_fd_sc_hd__or3b_2_0/A VGND VPWR VPWR VGND sky130_fd_sc_hd__nor2_2
Xsky130_fd_sc_hd__nor2_2_27 sky130_fd_sc_hd__o21a_2_3/A2 sky130_fd_sc_hd__o32a_2_1/B1
+ sky130_fd_sc_hd__nor2_2_3/B VGND VPWR VPWR VGND sky130_fd_sc_hd__nor2_2
Xsky130_fd_sc_hd__nor2_2_16 sky130_fd_sc_hd__or4_2_2/D sky130_fd_sc_hd__o21a_2_9/A2
+ sky130_fd_sc_hd__or4_2_2/C VGND VPWR VPWR VGND sky130_fd_sc_hd__nor2_2
Xsky130_fd_sc_hd__decap_3_20 VPWR VGND sky130_fd_sc_hd__decap_3_20/VPB VGND sky130_fd_sc_hd__decap_3
Xsky130_fd_sc_hd__decap_3_42 VPWR VGND sky130_fd_sc_hd__decap_3_77/VPB VGND sky130_fd_sc_hd__decap_3
Xsky130_fd_sc_hd__decap_3_53 VPWR VGND sky130_fd_sc_hd__decap_3_53/VPB VGND sky130_fd_sc_hd__decap_3
Xsky130_fd_sc_hd__decap_3_31 VPWR VGND sky130_fd_sc_hd__decap_3_33/VPB VGND sky130_fd_sc_hd__decap_3
Xsky130_fd_sc_hd__decap_3_97 VPWR VGND sky130_fd_sc_hd__decap_3_97/VPB VGND sky130_fd_sc_hd__decap_3
Xsky130_fd_sc_hd__decap_3_75 VPWR VGND sky130_fd_sc_hd__decap_3_75/VPB VGND sky130_fd_sc_hd__decap_3
Xsky130_fd_sc_hd__decap_3_64 VPWR VGND sky130_fd_sc_hd__decap_3_65/VPB VGND sky130_fd_sc_hd__decap_3
Xsky130_fd_sc_hd__decap_3_86 VPWR VGND sky130_fd_sc_hd__decap_3_86/VPB VGND sky130_fd_sc_hd__decap_3
Xsky130_fd_sc_hd__a31o_2_23 sky130_fd_sc_hd__a31o_2_23/X sky130_fd_sc_hd__nand4_2_10/C
+ sky130_fd_sc_hd__nand4_2_10/D I sky130_fd_sc_hd__inv_2_7/A VGND VPWR VPWR VGND sky130_fd_sc_hd__a31o_2
Xsky130_fd_sc_hd__a31o_2_12 sky130_fd_sc_hd__a31o_2_12/X sky130_fd_sc_hd__inv_2_11/A
+ sky130_fd_sc_hd__a221o_2_1/X I sky130_fd_sc_hd__inv_2_7/A VGND VPWR VPWR VGND sky130_fd_sc_hd__a31o_2
Xsky130_fd_sc_hd__and2_2_8 sky130_fd_sc_hd__and2_2_8/A sky130_fd_sc_hd__and2_2_8/X
+ sky130_fd_sc_hd__and2_2_8/B VPWR VGND sky130_fd_sc_hd__o22a_2_2/VPB VGND sky130_fd_sc_hd__and2_2
Xsky130_fd_sc_hd__xnor2_2_9 sky130_fd_sc_hd__or2_2_4/A sky130_fd_sc_hd__xor2_2_2/A
+ sky130_fd_sc_hd__xor2_2_2/B VGND VPWR VPWR VGND sky130_fd_sc_hd__xnor2_2
Xsky130_fd_sc_hd__or3_2_12 sky130_fd_sc_hd__or3_2_6/X sky130_fd_sc_hd__or3_2_17/B
+ sky130_fd_sc_hd__or3_2_12/X sky130_fd_sc_hd__or3_2_17/C VGND VPWR VPWR VGND sky130_fd_sc_hd__or3_2
Xsky130_fd_sc_hd__a31o_2_4 sky130_fd_sc_hd__a31o_2_4/X sky130_fd_sc_hd__nand4_2_3/C
+ sky130_fd_sc_hd__nand4_2_3/D I sky130_fd_sc_hd__inv_2_7/A VGND VPWR VPWR VGND sky130_fd_sc_hd__a31o_2
Xsky130_fd_sc_hd__and4bb_2_2 sky130_fd_sc_hd__or4b_2_3/A sky130_fd_sc_hd__or4b_2_3/C
+ sky130_fd_sc_hd__or4b_2_2/C sky130_fd_sc_hd__nand4_2_1/D sky130_fd_sc_hd__or4b_2_3/B
+ VGND VPWR VPWR VGND sky130_fd_sc_hd__and4bb_2
Xsky130_fd_sc_hd__clkbuf_8_10 sky130_fd_sc_hd__clkbuf_8_10/X sky130_fd_sc_hd__clkbuf_8_9/A
+ VGND VPWR VPWR VGND sky130_fd_sc_hd__clkbuf_8
Xsky130_fd_sc_hd__decap_3_116 VPWR VGND sky130_fd_sc_hd__decap_3_116/VPB VGND sky130_fd_sc_hd__decap_3
Xsky130_fd_sc_hd__decap_3_105 VPWR VGND sky130_fd_sc_hd__decap_3_93/VPB VGND sky130_fd_sc_hd__decap_3
Xsky130_fd_sc_hd__decap_3_127 VPWR VGND sky130_fd_sc_hd__decap_3_129/VPB VGND sky130_fd_sc_hd__decap_3
Xsky130_fd_sc_hd__decap_3_138 VPWR VGND sky130_fd_sc_hd__decap_3_138/VPB VGND sky130_fd_sc_hd__decap_3
Xsky130_fd_sc_hd__decap_3_149 VPWR VGND sky130_fd_sc_hd__decap_3_149/VPB VGND sky130_fd_sc_hd__decap_3
Xsky130_fd_sc_hd__o21ai_2_3 sky130_fd_sc_hd__o21ai_2_3/B1 sky130_fd_sc_hd__o21ai_2_3/Y
+ sky130_fd_sc_hd__nor2_2_40/A I VGND VPWR VPWR VGND sky130_fd_sc_hd__o21ai_2
Xsky130_fd_sc_hd__a21o_2_3 sky130_fd_sc_hd__a21o_2_3/X sky130_fd_sc_hd__and3_2_3/X
+ sky130_fd_sc_hd__or2_2_5/A sky130_fd_sc_hd__a21o_2_3/A2 VGND VPWR VPWR VGND sky130_fd_sc_hd__a21o_2
Xsky130_fd_sc_hd__or2_2_4 sky130_fd_sc_hd__or2_2_4/B sky130_fd_sc_hd__or2_2_4/X sky130_fd_sc_hd__or2_2_4/A
+ VPWR VGND VPWR VGND sky130_fd_sc_hd__or2_2
Xsky130_fd_sc_hd__nand2b_2_18 sky130_fd_sc_hd__o21a_2_24/A2 sky130_fd_sc_hd__dfrtp_2_67/D
+ sky130_fd_sc_hd__o21a_2_24/A1 VGND VPWR sky130_fd_sc_hd__a31o_2_20/VPB VGND sky130_fd_sc_hd__nand2b_2
Xsky130_fd_sc_hd__nor2_2_17 sky130_fd_sc_hd__and3_2_2/C sky130_fd_sc_hd__or3_2_5/B
+ sky130_fd_sc_hd__and3_2_2/A VGND VPWR VPWR VGND sky130_fd_sc_hd__nor2_2
Xsky130_fd_sc_hd__nor2_2_28 sky130_fd_sc_hd__and2_2_2/A sky130_fd_sc_hd__or3_2_1/B
+ sky130_fd_sc_hd__or3_2_3/B VGND VPWR VPWR VGND sky130_fd_sc_hd__nor2_2
Xsky130_fd_sc_hd__nor2_2_39 sky130_fd_sc_hd__inv_2_7/A sky130_fd_sc_hd__nor2_2_39/Y
+ sky130_fd_sc_hd__or2_2_10/A VGND VPWR VPWR VGND sky130_fd_sc_hd__nor2_2
Xsky130_fd_sc_hd__decap_3_10 VPWR VGND sky130_fd_sc_hd__decap_3_20/VPB VGND sky130_fd_sc_hd__decap_3
Xsky130_fd_sc_hd__decap_3_21 VPWR VGND sky130_fd_sc_hd__decap_3_27/VPB VGND sky130_fd_sc_hd__decap_3
Xsky130_fd_sc_hd__decap_3_43 VPWR VGND sky130_fd_sc_hd__decap_3_43/VPB VGND sky130_fd_sc_hd__decap_3
Xsky130_fd_sc_hd__decap_3_54 VPWR VGND sky130_fd_sc_hd__decap_3_54/VPB VGND sky130_fd_sc_hd__decap_3
Xsky130_fd_sc_hd__decap_3_32 VPWR VGND sky130_fd_sc_hd__decap_3_34/VPB VGND sky130_fd_sc_hd__decap_3
Xsky130_fd_sc_hd__decap_3_76 VPWR VGND sky130_fd_sc_hd__decap_3_76/VPB VGND sky130_fd_sc_hd__decap_3
Xsky130_fd_sc_hd__decap_3_65 VPWR VGND sky130_fd_sc_hd__decap_3_65/VPB VGND sky130_fd_sc_hd__decap_3
Xsky130_fd_sc_hd__decap_3_87 VPWR VGND sky130_fd_sc_hd__decap_3_87/VPB VGND sky130_fd_sc_hd__decap_3
Xsky130_fd_sc_hd__decap_3_98 VPWR VGND sky130_fd_sc_hd__decap_3_98/VPB VGND sky130_fd_sc_hd__decap_3
Xsky130_fd_sc_hd__a31o_2_13 sky130_fd_sc_hd__a31o_2_13/X sky130_fd_sc_hd__or2_2_11/A
+ sky130_fd_sc_hd__inv_2_7/A sky130_fd_sc_hd__inv_2_9/A sky130_fd_sc_hd__nor2_2_29/Y
+ VGND VPWR VPWR VGND sky130_fd_sc_hd__a31o_2
Xsky130_fd_sc_hd__a31o_2_24 sky130_fd_sc_hd__a31o_2_24/X sky130_fd_sc_hd__nand4_2_9/C
+ sky130_fd_sc_hd__nand4_2_9/D I sky130_fd_sc_hd__inv_2_7/A VGND VPWR VPWR VGND sky130_fd_sc_hd__a31o_2
Xsky130_fd_sc_hd__and2_2_9 sky130_fd_sc_hd__and4_2_3/C sky130_fd_sc_hd__and4_2_4/B
+ sky130_fd_sc_hd__nor3_2_2/A VPWR VGND VPWR VGND sky130_fd_sc_hd__and2_2
Xsky130_fd_sc_hd__or3_2_13 sky130_fd_sc_hd__or3_2_13/A sky130_fd_sc_hd__or3_2_17/B
+ sky130_fd_sc_hd__or3_2_13/X sky130_fd_sc_hd__or3_2_17/C VGND VPWR VPWR VGND sky130_fd_sc_hd__or3_2
Xsky130_fd_sc_hd__a31o_2_5 sky130_fd_sc_hd__a31o_2_5/X sky130_fd_sc_hd__xor2_2_5/X
+ sky130_fd_sc_hd__a31o_2_5/A3 sky130_fd_sc_hd__or2_2_5/A sky130_fd_sc_hd__a31o_2_5/A2
+ VGND VPWR VPWR VGND sky130_fd_sc_hd__a31o_2
Xsky130_fd_sc_hd__xnor2_2_20 sky130_fd_sc_hd__xnor2_2_21/B sky130_fd_sc_hd__or2_2_12/A
+ sky130_fd_sc_hd__xor2_2_20/A VGND VPWR VPWR VGND sky130_fd_sc_hd__xnor2_2
Xsky130_fd_sc_hd__and4bb_2_3 sky130_fd_sc_hd__or4b_2_3/B sky130_fd_sc_hd__or4b_2_3/C
+ sky130_fd_sc_hd__or4b_2_2/C sky130_fd_sc_hd__nand4_2_2/D sky130_fd_sc_hd__or4b_2_3/A
+ VGND VPWR VPWR VGND sky130_fd_sc_hd__and4bb_2
Xsky130_fd_sc_hd__clkbuf_8_11 sky130_fd_sc_hd__clkbuf_8_11/X sky130_fd_sc_hd__clkbuf_8_9/A
+ VGND VPWR VPWR VGND sky130_fd_sc_hd__clkbuf_8
Xsky130_fd_sc_hd__decap_3_106 VPWR VGND sky130_fd_sc_hd__decap_3_107/VPB VGND sky130_fd_sc_hd__decap_3
Xsky130_fd_sc_hd__decap_3_128 VPWR VGND sky130_fd_sc_hd__decap_3_131/VPB VGND sky130_fd_sc_hd__decap_3
Xsky130_fd_sc_hd__decap_3_117 VPWR VGND sky130_fd_sc_hd__decap_3_118/VPB VGND sky130_fd_sc_hd__decap_3
Xsky130_fd_sc_hd__decap_3_139 VPWR VGND sky130_fd_sc_hd__decap_3_139/VPB VGND sky130_fd_sc_hd__decap_3
Xsky130_fd_sc_hd__o21ai_2_4 sky130_fd_sc_hd__a211o_2_3/X sky130_fd_sc_hd__o21ai_2_4/Y
+ sky130_fd_sc_hd__o32a_2_2/B2 sky130_fd_sc_hd__inv_2_12/Y VGND VPWR VPWR VGND sky130_fd_sc_hd__o21ai_2
Xsky130_fd_sc_hd__nand3_2_0 sky130_fd_sc_hd__xor2_2_9/A sky130_fd_sc_hd__nand3_2_0/Y
+ sky130_fd_sc_hd__xor2_2_4/A sky130_fd_sc_hd__inv_2_5/A VGND VPWR VPWR VGND sky130_fd_sc_hd__nand3_2
Xsky130_fd_sc_hd__mux2_1_0 sky130_fd_sc_hd__or4_2_0/A sky130_fd_sc_hd__a31o_2_0/X
+ sky130_fd_sc_hd__o21a_2_3/X sky130_fd_sc_hd__mux2_1_0/X VGND VPWR VPWR VGND sky130_fd_sc_hd__mux2_1
Xsky130_fd_sc_hd__a21o_2_4 sky130_fd_sc_hd__xor2_2_5/B sky130_fd_sc_hd__a21oi_2_6/Y
+ sky130_fd_sc_hd__xnor2_2_4/A sky130_fd_sc_hd__or3_2_5/B VGND VPWR VPWR VGND sky130_fd_sc_hd__a21o_2
Xsky130_fd_sc_hd__or2_2_5 sky130_fd_sc_hd__or3_2_1/B sky130_fd_sc_hd__or2_2_5/X sky130_fd_sc_hd__or2_2_5/A
+ VPWR VGND VPWR VGND sky130_fd_sc_hd__or2_2
Xsky130_fd_sc_hd__nand2b_2_19 sky130_fd_sc_hd__o21a_2_25/A2 sky130_fd_sc_hd__dfrtp_2_68/D
+ sky130_fd_sc_hd__o21a_2_25/A1 VGND VPWR VPWR VGND sky130_fd_sc_hd__nand2b_2
Xsky130_fd_sc_hd__and2b_2_0 sky130_fd_sc_hd__or2_2_0/B sky130_fd_sc_hd__nor2_2_9/B
+ sky130_fd_sc_hd__xor2_2_3/B VPWR VGND VPWR VGND sky130_fd_sc_hd__and2b_2
Xsky130_fd_sc_hd__nor2_2_18 sky130_fd_sc_hd__xor2_2_5/B sky130_fd_sc_hd__nor2_2_20/A
+ sky130_fd_sc_hd__xor2_2_5/A VGND VPWR VPWR VGND sky130_fd_sc_hd__nor2_2
Xsky130_fd_sc_hd__nor2_2_29 sky130_fd_sc_hd__and3_2_7/C sky130_fd_sc_hd__nor2_2_29/Y
+ sky130_fd_sc_hd__xor2_2_7/A VGND VPWR VPWR VGND sky130_fd_sc_hd__nor2_2
Xsky130_fd_sc_hd__decap_3_11 VPWR VGND sky130_fd_sc_hd__decap_3_12/VPB VGND sky130_fd_sc_hd__decap_3
Xsky130_fd_sc_hd__decap_3_44 VPWR VGND sky130_fd_sc_hd__decap_3_44/VPB VGND sky130_fd_sc_hd__decap_3
Xsky130_fd_sc_hd__decap_3_22 VPWR VGND sky130_fd_sc_hd__decap_3_25/VPB VGND sky130_fd_sc_hd__decap_3
Xsky130_fd_sc_hd__decap_3_33 VPWR VGND sky130_fd_sc_hd__decap_3_33/VPB VGND sky130_fd_sc_hd__decap_3
Xsky130_fd_sc_hd__decap_3_77 VPWR VGND sky130_fd_sc_hd__decap_3_77/VPB VGND sky130_fd_sc_hd__decap_3
Xsky130_fd_sc_hd__decap_3_55 VPWR VGND sky130_fd_sc_hd__decap_3_57/VPB VGND sky130_fd_sc_hd__decap_3
Xsky130_fd_sc_hd__decap_3_66 VPWR VGND sky130_fd_sc_hd__decap_3_66/VPB VGND sky130_fd_sc_hd__decap_3
Xsky130_fd_sc_hd__decap_3_88 VPWR VGND sky130_fd_sc_hd__decap_3_88/VPB VGND sky130_fd_sc_hd__decap_3
Xsky130_fd_sc_hd__decap_3_99 VPWR VGND sky130_fd_sc_hd__decap_3_99/VPB VGND sky130_fd_sc_hd__decap_3
Xsky130_fd_sc_hd__a31o_2_14 sky130_fd_sc_hd__a31o_2_14/X sky130_fd_sc_hd__a22o_2_4/X
+ sky130_fd_sc_hd__or2_2_12/X sky130_fd_sc_hd__and2b_2_16/X sky130_fd_sc_hd__nand2_2_38/Y
+ VGND VPWR VPWR VGND sky130_fd_sc_hd__a31o_2
Xsky130_fd_sc_hd__a31o_2_25 sky130_fd_sc_hd__a31o_2_25/X sky130_fd_sc_hd__nand4_2_5/C
+ sky130_fd_sc_hd__nand4_2_5/D I sky130_fd_sc_hd__inv_2_7/A VGND VPWR VPWR VGND sky130_fd_sc_hd__a31o_2
Xsky130_fd_sc_hd__or3_2_14 sky130_fd_sc_hd__or3_2_14/A sky130_fd_sc_hd__or3_2_17/B
+ sky130_fd_sc_hd__or3_2_14/X sky130_fd_sc_hd__or3_2_17/C VGND VPWR VPWR VGND sky130_fd_sc_hd__or3_2
Xsky130_fd_sc_hd__a31o_2_6 sky130_fd_sc_hd__or3_2_11/A sky130_fd_sc_hd__nor3_2_0/Y
+ sky130_fd_sc_hd__nor2_2_24/Y sky130_fd_sc_hd__or3b_2_0/A sky130_fd_sc_hd__or2_2_9/B
+ VGND VPWR VPWR VGND sky130_fd_sc_hd__a31o_2
Xsky130_fd_sc_hd__xnor2_2_10 sky130_fd_sc_hd__or4_2_0/B sky130_fd_sc_hd__xor2_2_6/A
+ sky130_fd_sc_hd__xor2_2_6/B VGND VPWR VPWR VGND sky130_fd_sc_hd__xnor2_2
Xsky130_fd_sc_hd__xnor2_2_21 sky130_fd_sc_hd__xnor2_2_21/Y sky130_fd_sc_hd__a22o_2_4/B2
+ sky130_fd_sc_hd__xnor2_2_21/B VGND VPWR VPWR VGND sky130_fd_sc_hd__xnor2_2
Xsky130_fd_sc_hd__and4bb_2_4 sky130_fd_sc_hd__or2_2_9/B sky130_fd_sc_hd__or3b_2_0/A
+ sky130_fd_sc_hd__or2_2_8/B sky130_fd_sc_hd__or3_2_14/A sky130_fd_sc_hd__or2_2_9/A
+ VGND VPWR VPWR VGND sky130_fd_sc_hd__and4bb_2
Xsky130_fd_sc_hd__clkbuf_8_12 sky130_fd_sc_hd__dfxtp_2_2/CLK sky130_fd_sc_hd__clkbuf_8_9/A
+ VGND VPWR sky130_fd_sc_hd__clkbuf_8_12/VPB VGND sky130_fd_sc_hd__clkbuf_8
Xsky130_fd_sc_hd__decap_3_107 VPWR VGND sky130_fd_sc_hd__decap_3_107/VPB VGND sky130_fd_sc_hd__decap_3
Xsky130_fd_sc_hd__decap_3_129 VPWR VGND sky130_fd_sc_hd__decap_3_129/VPB VGND sky130_fd_sc_hd__decap_3
Xsky130_fd_sc_hd__decap_3_118 VPWR VGND sky130_fd_sc_hd__decap_3_118/VPB VGND sky130_fd_sc_hd__decap_3
Xsky130_fd_sc_hd__o21ai_2_5 sky130_fd_sc_hd__or2_2_8/B sky130_fd_sc_hd__o21ai_2_5/Y
+ sky130_fd_sc_hd__or2_2_9/B sky130_fd_sc_hd__or2_2_9/A VGND VPWR sky130_fd_sc_hd__or2_2_8/VPB
+ VGND sky130_fd_sc_hd__o21ai_2
Xsky130_fd_sc_hd__nand3_2_1 sky130_fd_sc_hd__or2_2_9/B sky130_fd_sc_hd__nand3_2_1/Y
+ sky130_fd_sc_hd__or2_2_9/A sky130_fd_sc_hd__or3b_2_0/A VGND VPWR VPWR VGND sky130_fd_sc_hd__nand3_2
Xsky130_fd_sc_hd__mux2_1_1 sky130_fd_sc_hd__or3_2_3/B sky130_fd_sc_hd__or4_2_0/C sky130_fd_sc_hd__or3_2_0/X
+ sky130_fd_sc_hd__mux2_1_1/X VGND VPWR VPWR VGND sky130_fd_sc_hd__mux2_1
Xsky130_fd_sc_hd__a21o_2_5 sky130_fd_sc_hd__xor2_2_6/A sky130_fd_sc_hd__nor2_2_21/A
+ sky130_fd_sc_hd__xor2_2_8/A sky130_fd_sc_hd__xor2_2_8/B VGND VPWR VPWR VGND sky130_fd_sc_hd__a21o_2
Xsky130_fd_sc_hd__o32ai_2_0 sky130_fd_sc_hd__o31a_2_0/A1 sky130_fd_sc_hd__o32ai_2_0/B1
+ sky130_fd_sc_hd__o31a_2_0/A2 sky130_fd_sc_hd__and2_2_7/X sky130_fd_sc_hd__o32ai_2_0/Y
+ sky130_fd_sc_hd__or3b_2_0/A VGND VPWR VPWR VGND sky130_fd_sc_hd__o32ai_2
Xsky130_fd_sc_hd__or2_2_6 sky130_fd_sc_hd__or2_2_6/B sky130_fd_sc_hd__or2_2_6/X sky130_fd_sc_hd__or3_2_1/C
+ VPWR VGND VPWR VGND sky130_fd_sc_hd__or2_2
Xsky130_fd_sc_hd__o21ba_2_0 sky130_fd_sc_hd__nor2_2_5/Y sky130_fd_sc_hd__or2_2_4/A
+ sky130_fd_sc_hd__o21ba_2_0/X sky130_fd_sc_hd__nand2_2_9/Y VGND VPWR VPWR VGND sky130_fd_sc_hd__o21ba_2
Xsky130_fd_sc_hd__and2b_2_1 sky130_fd_sc_hd__and4_2_0/B sky130_fd_sc_hd__o21a_2_4/A1
+ sky130_fd_sc_hd__nand4_2_0/C VPWR VGND sky130_fd_sc_hd__nand4_2_0/VPB VGND sky130_fd_sc_hd__and2b_2
Xsky130_fd_sc_hd__or4bb_2_0 sky130_fd_sc_hd__or4_2_4/A sky130_fd_sc_hd__or4bb_2_0/X
+ sky130_fd_sc_hd__or4_2_4/C sky130_fd_sc_hd__or4_2_4/B sky130_fd_sc_hd__or4_2_4/D
+ VPWR VGND VPWR VGND sky130_fd_sc_hd__or4bb_2
Xsky130_fd_sc_hd__nor2_2_19 sky130_fd_sc_hd__xnor2_2_8/B sky130_fd_sc_hd__nor2_2_19/Y
+ sky130_fd_sc_hd__xnor2_2_8/A VGND VPWR VPWR VGND sky130_fd_sc_hd__nor2_2
Xsky130_fd_sc_hd__decap_3_45 VPWR VGND sky130_fd_sc_hd__decap_3_45/VPB VGND sky130_fd_sc_hd__decap_3
Xsky130_fd_sc_hd__decap_3_12 VPWR VGND sky130_fd_sc_hd__decap_3_12/VPB VGND sky130_fd_sc_hd__decap_3
Xsky130_fd_sc_hd__decap_3_23 VPWR VGND sky130_fd_sc_hd__decap_3_24/VPB VGND sky130_fd_sc_hd__decap_3
Xsky130_fd_sc_hd__decap_3_34 VPWR VGND sky130_fd_sc_hd__decap_3_34/VPB VGND sky130_fd_sc_hd__decap_3
Xsky130_fd_sc_hd__decap_3_56 VPWR VGND sky130_fd_sc_hd__decap_3_56/VPB VGND sky130_fd_sc_hd__decap_3
Xsky130_fd_sc_hd__decap_3_67 VPWR VGND sky130_fd_sc_hd__decap_3_67/VPB VGND sky130_fd_sc_hd__decap_3
Xsky130_fd_sc_hd__decap_3_78 VPWR VGND sky130_fd_sc_hd__decap_3_84/VPB VGND sky130_fd_sc_hd__decap_3
Xsky130_fd_sc_hd__decap_3_89 VPWR VGND sky130_fd_sc_hd__decap_3_90/VPB VGND sky130_fd_sc_hd__decap_3
Xsky130_fd_sc_hd__a31o_2_15 sky130_fd_sc_hd__a31o_2_15/X sky130_fd_sc_hd__a22oi_2_0/Y
+ sky130_fd_sc_hd__nand2_2_29/Y sky130_fd_sc_hd__or2_2_9/B sky130_fd_sc_hd__inv_2_13/Y
+ VGND VPWR VPWR VGND sky130_fd_sc_hd__a31o_2
Xsky130_fd_sc_hd__nand4_2_10 sky130_fd_sc_hd__inv_2_7/A I sky130_fd_sc_hd__o21a_2_28/A2
+ sky130_fd_sc_hd__nand4_2_10/D sky130_fd_sc_hd__nand4_2_10/C VGND VPWR VPWR VGND
+ sky130_fd_sc_hd__nand4_2
Xsky130_fd_sc_hd__or3_2_15 sky130_fd_sc_hd__or3_2_15/A sky130_fd_sc_hd__or3_2_17/B
+ sky130_fd_sc_hd__or3_2_15/X sky130_fd_sc_hd__or3_2_17/C VGND VPWR VPWR VGND sky130_fd_sc_hd__or3_2
Xsky130_fd_sc_hd__a31o_2_7 sky130_fd_sc_hd__a31o_2_7/X sky130_fd_sc_hd__or3_2_5/B
+ sky130_fd_sc_hd__xor2_2_4/A sky130_fd_sc_hd__xor2_2_0/B sky130_fd_sc_hd__xor2_2_9/A
+ VGND VPWR VPWR VGND sky130_fd_sc_hd__a31o_2
Xsky130_fd_sc_hd__xnor2_2_22 sky130_fd_sc_hd__xnor2_2_22/Y sky130_fd_sc_hd__or2_2_12/A
+ sky130_fd_sc_hd__o21ai_2_4/Y VGND VPWR VPWR VGND sky130_fd_sc_hd__xnor2_2
Xsky130_fd_sc_hd__xnor2_2_11 sky130_fd_sc_hd__xnor2_2_11/Y sky130_fd_sc_hd__and4_2_3/C
+ sky130_fd_sc_hd__xnor2_2_11/B VGND VPWR VPWR VGND sky130_fd_sc_hd__xnor2_2
Xsky130_fd_sc_hd__and4bb_2_5 sky130_fd_sc_hd__and4_2_3/B sky130_fd_sc_hd__nor3_2_2/B
+ sky130_fd_sc_hd__or3_2_8/C sky130_fd_sc_hd__and3_2_10/A sky130_fd_sc_hd__or3_2_8/B
+ VGND VPWR VPWR VGND sky130_fd_sc_hd__and4bb_2
Xsky130_fd_sc_hd__clkbuf_8_13 sky130_fd_sc_hd__clkbuf_4_9/A sky130_fd_sc_hd__clkbuf_8_9/A
+ VGND VPWR sky130_fd_sc_hd__clkbuf_4_9/VPB VGND sky130_fd_sc_hd__clkbuf_8
Xsky130_fd_sc_hd__decap_3_119 VPWR VGND sky130_fd_sc_hd__decap_3_119/VPB VGND sky130_fd_sc_hd__decap_3
Xsky130_fd_sc_hd__decap_3_108 VPWR VGND sky130_fd_sc_hd__decap_3_121/VPB VGND sky130_fd_sc_hd__decap_3
Xsky130_fd_sc_hd__nor3b_2_0 sky130_fd_sc_hd__nor2_2_40/A sky130_fd_sc_hd__o22a_2_3/B1
+ sky130_fd_sc_hd__inv_2_7/A sky130_fd_sc_hd__nor3b_2_0/B VGND VPWR VPWR VGND sky130_fd_sc_hd__nor3b_2
Xsky130_fd_sc_hd__mux2_1_2 sky130_fd_sc_hd__or4_2_0/A sky130_fd_sc_hd__a22o_2_0/X
+ sky130_fd_sc_hd__or2_2_6/X sky130_fd_sc_hd__mux2_1_2/X VGND VPWR VPWR VGND sky130_fd_sc_hd__mux2_1
Xsky130_fd_sc_hd__a21o_2_6 sky130_fd_sc_hd__a21o_2_6/X sky130_fd_sc_hd__or2_2_9/A
+ sky130_fd_sc_hd__and2_2_7/B sky130_fd_sc_hd__a21o_2_6/A2 VGND VPWR VPWR VGND sky130_fd_sc_hd__a21o_2
Xsky130_fd_sc_hd__or2_2_7 I sky130_fd_sc_hd__or2_2_7/X sky130_fd_sc_hd__or2_2_7/A
+ VPWR VGND VPWR VGND sky130_fd_sc_hd__or2_2
Xsky130_fd_sc_hd__o21ba_2_1 sky130_fd_sc_hd__or4b_2_8/C success sky130_fd_sc_hd__o21ba_2_1/X
+ sky130_fd_sc_hd__a32o_2_3/B1 VGND VPWR VPWR VGND sky130_fd_sc_hd__o21ba_2
Xsky130_fd_sc_hd__and2b_2_2 sky130_fd_sc_hd__and4_2_0/C sky130_fd_sc_hd__o21a_2_5/A1
+ sky130_fd_sc_hd__nand4_2_3/C VPWR VGND VPWR VGND sky130_fd_sc_hd__and2b_2
Xsky130_fd_sc_hd__o31ai_2_0 sky130_fd_sc_hd__or2_2_4/A sky130_fd_sc_hd__o32a_2_1/B2
+ sky130_fd_sc_hd__or4_2_0/A sky130_fd_sc_hd__inv_2_0/Y sky130_fd_sc_hd__or3_2_2/C
+ VGND VPWR VPWR VGND sky130_fd_sc_hd__o31ai_2
Xsky130_fd_sc_hd__decap_3_13 VPWR VGND sky130_fd_sc_hd__decap_3_14/VPB VGND sky130_fd_sc_hd__decap_3
Xsky130_fd_sc_hd__decap_3_24 VPWR VGND sky130_fd_sc_hd__decap_3_24/VPB VGND sky130_fd_sc_hd__decap_3
Xsky130_fd_sc_hd__decap_3_35 VPWR VGND sky130_fd_sc_hd__decap_3_35/VPB VGND sky130_fd_sc_hd__decap_3
Xsky130_fd_sc_hd__decap_3_46 VPWR VGND sky130_fd_sc_hd__decap_3_54/VPB VGND sky130_fd_sc_hd__decap_3
Xsky130_fd_sc_hd__decap_3_57 VPWR VGND sky130_fd_sc_hd__decap_3_57/VPB VGND sky130_fd_sc_hd__decap_3
Xsky130_fd_sc_hd__decap_3_68 VPWR VGND sky130_fd_sc_hd__decap_3_69/VPB VGND sky130_fd_sc_hd__decap_3
Xsky130_fd_sc_hd__decap_3_79 VPWR VGND sky130_fd_sc_hd__decap_3_91/VPB VGND sky130_fd_sc_hd__decap_3
Xsky130_fd_sc_hd__a31o_2_16 sky130_fd_sc_hd__a31o_2_16/X sky130_fd_sc_hd__nand4_2_6/C
+ sky130_fd_sc_hd__nand4_2_6/D I sky130_fd_sc_hd__inv_2_7/A VGND VPWR VPWR VGND sky130_fd_sc_hd__a31o_2
Xsky130_fd_sc_hd__nand4_2_11 sky130_fd_sc_hd__inv_2_7/A I sky130_fd_sc_hd__o21a_2_24/A2
+ sky130_fd_sc_hd__and4b_2_2/X sky130_fd_sc_hd__nand4_2_11/C VGND VPWR VPWR VGND sky130_fd_sc_hd__nand4_2
Xsky130_fd_sc_hd__or3_2_16 sky130_fd_sc_hd__or3_2_16/A sky130_fd_sc_hd__or3_2_17/B
+ sky130_fd_sc_hd__or3_2_16/X sky130_fd_sc_hd__or3_2_17/C VGND VPWR VPWR VGND sky130_fd_sc_hd__or3_2
Xsky130_fd_sc_hd__a31o_2_8 sky130_fd_sc_hd__a31o_2_8/X sky130_fd_sc_hd__xor2_2_0/B
+ sky130_fd_sc_hd__xor2_2_7/A sky130_fd_sc_hd__inv_2_9/A sky130_fd_sc_hd__inv_2_7/A
+ VGND VPWR VPWR VGND sky130_fd_sc_hd__a31o_2
Xsky130_fd_sc_hd__xnor2_2_23 sky130_fd_sc_hd__or2_2_12/B sky130_fd_sc_hd__a22o_2_4/B2
+ sky130_fd_sc_hd__xnor2_2_26/A VGND VPWR VPWR VGND sky130_fd_sc_hd__xnor2_2
Xsky130_fd_sc_hd__and4bb_2_6 sky130_fd_sc_hd__or4_2_4/A sky130_fd_sc_hd__or4_2_4/D
+ sky130_fd_sc_hd__or4_2_4/C sky130_fd_sc_hd__inv_2_9/A sky130_fd_sc_hd__or4_2_4/B
+ VGND VPWR VPWR VGND sky130_fd_sc_hd__and4bb_2
Xsky130_fd_sc_hd__xnor2_2_12 sky130_fd_sc_hd__nor2_2_31/B sky130_fd_sc_hd__or4_2_4/A
+ sky130_fd_sc_hd__inv_2_7/A VGND VPWR VPWR VGND sky130_fd_sc_hd__xnor2_2
Xsky130_fd_sc_hd__clkbuf_8_14 sky130_fd_sc_hd__dfxtp_2_3/CLK sky130_fd_sc_hd__clkbuf_8_9/A
+ VGND VPWR sky130_fd_sc_hd__clkbuf_8_14/VPB VGND sky130_fd_sc_hd__clkbuf_8
Xsky130_fd_sc_hd__decap_3_109 VPWR VGND sky130_fd_sc_hd__decap_3_111/VPB VGND sky130_fd_sc_hd__decap_3
Xsky130_fd_sc_hd__nor3b_2_1 sky130_fd_sc_hd__or2_2_9/A sky130_fd_sc_hd__o31a_2_2/A3
+ sky130_fd_sc_hd__or3b_2_0/A sky130_fd_sc_hd__or2_2_9/B VGND VPWR VPWR VGND sky130_fd_sc_hd__nor3b_2
Xsky130_fd_sc_hd__clkbuf_8_0 sky130_fd_sc_hd__clkbuf_8_0/X sky130_fd_sc_hd__clkbuf_8_9/A
+ VGND VPWR VPWR VGND sky130_fd_sc_hd__clkbuf_8
Xsky130_fd_sc_hd__mux2_1_3 sky130_fd_sc_hd__or2_2_5/A sky130_fd_sc_hd__mux2_1_0/X
+ sky130_fd_sc_hd__o32a_2_1/X sky130_fd_sc_hd__mux2_1_3/X VGND VPWR VPWR VGND sky130_fd_sc_hd__mux2_1
Xsky130_fd_sc_hd__a21o_2_7 sky130_fd_sc_hd__or3_2_10/A sky130_fd_sc_hd__or3_2_6/C
+ sky130_fd_sc_hd__or3b_2_0/A sky130_fd_sc_hd__nor2_2_24/Y VGND VPWR sky130_fd_sc_hd__a21o_2_7/VPB
+ VGND sky130_fd_sc_hd__a21o_2
.ends
